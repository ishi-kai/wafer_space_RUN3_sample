* NGSPICE file created from r2r_ladder_8bit.ext - technology: gf180mcuD

.subckt r2r_ladder_8bit VSS term in[7] in[6] in[5] in[4] in[3] in[2] in[1] in[0] out
X0 a_8954_3092# a_8954_3652# VSS ppolyf_u_1k_6p0 r_width=1u r_length=20u
X1 a_8954_292# a_8954_1412# VSS ppolyf_u_1k_6p0 r_width=1u r_length=20u
X2 in[6] a_4570_4212# VSS ppolyf_u_1k_6p0 r_width=1u r_length=19.8u
X3 in[0] a_4570_852# VSS ppolyf_u_1k_6p0 r_width=1u r_length=19.8u
X4 in[2] a_4570_1972# VSS ppolyf_u_1k_6p0 r_width=1u r_length=19.8u
X5 a_4570_4212# a_8954_4212# VSS ppolyf_u_1k_6p0 r_width=1u r_length=19.8u
X6 a_4570_852# a_8954_292# VSS ppolyf_u_1k_6p0 r_width=1u r_length=19.8u
X7 in[4] a_4570_3092# VSS ppolyf_u_1k_6p0 r_width=1u r_length=19.8u
X8 a_8954_1412# a_8954_1972# VSS ppolyf_u_1k_6p0 r_width=1u r_length=20u
X9 a_4570_1972# a_8954_1972# VSS ppolyf_u_1k_6p0 r_width=1u r_length=19.8u
X10 a_8954_2532# a_8954_3092# VSS ppolyf_u_1k_6p0 r_width=1u r_length=20u
X11 a_8954_3652# a_8954_4212# VSS ppolyf_u_1k_6p0 r_width=1u r_length=20u
X12 a_4570_3092# a_8954_3092# VSS ppolyf_u_1k_6p0 r_width=1u r_length=19.8u
X13 in[1] a_4570_1412# VSS ppolyf_u_1k_6p0 r_width=1u r_length=19.8u
X14 in[3] a_4570_2532# VSS ppolyf_u_1k_6p0 r_width=1u r_length=19.8u
X15 in[5] a_4570_3652# VSS ppolyf_u_1k_6p0 r_width=1u r_length=19.8u
X16 in[7] a_4570_4772# VSS ppolyf_u_1k_6p0 r_width=1u r_length=19.8u
X17 a_4570_1412# a_8954_1412# VSS ppolyf_u_1k_6p0 r_width=1u r_length=19.8u
X18 a_4570_2532# a_8954_2532# VSS ppolyf_u_1k_6p0 r_width=1u r_length=19.8u
X19 term a_4570_292# VSS ppolyf_u_1k_6p0 r_width=1u r_length=19.8u
X20 a_4570_3652# a_8954_3652# VSS ppolyf_u_1k_6p0 r_width=1u r_length=19.8u
X21 a_8954_4212# out VSS ppolyf_u_1k_6p0 r_width=1u r_length=20u
X22 a_4570_4772# out VSS ppolyf_u_1k_6p0 r_width=1u r_length=19.8u
X23 a_4570_292# a_8954_292# VSS ppolyf_u_1k_6p0 r_width=1u r_length=19.8u
X24 a_8954_1972# a_8954_2532# VSS ppolyf_u_1k_6p0 r_width=1u r_length=20u
C0 a_4570_2532# a_4570_3092# 0.03755f
C1 a_8954_3652# a_8954_4212# 0.45579f
C2 a_258_292# term 0.02244f
C3 a_8954_292# a_8954_1412# 0.08468f
C4 in[6] in[5] 0.0246f
C5 a_258_1412# a_258_1972# 0.00254f
C6 a_13650_4212# out 0.02084f
C7 in[0] in[1] 0.0246f
C8 a_4570_4212# a_4570_3652# 0.03755f
C9 a_4570_4212# a_4570_4772# 0.03755f
C10 in[1] in[2] 0.0246f
C11 a_13650_852# a_8954_1412# 0.02084f
C12 in[3] in[2] 0.0246f
C13 a_8954_4212# out 0.45498f
C14 a_258_2532# a_258_3092# 0.00254f
C15 a_8954_4212# a_9226_4772# 0.00172f
C16 a_258_3652# in[5] 0.02244f
C17 a_13650_852# a_13650_1412# 0.00254f
C18 a_13650_3092# a_13650_3652# 0.00254f
C19 a_4570_1972# a_4570_2532# 0.03755f
C20 a_258_852# in[0] 0.02244f
C21 a_8954_3652# a_13650_3092# 0.02084f
C22 in[3] in[4] 0.0246f
C23 in[4] in[5] 0.0246f
C24 a_258_3652# a_258_3092# 0.00254f
C25 a_8954_3652# a_8954_3092# 0.45579f
C26 a_258_852# a_258_292# 0.00254f
C27 a_4570_3092# a_4570_3652# 0.03755f
C28 a_258_1412# in[1] 0.02244f
C29 a_13650_2532# a_13650_3092# 0.00254f
C30 a_258_3092# in[4] 0.02244f
C31 a_4570_852# a_4570_292# 0.03755f
C32 a_4570_1412# a_4570_1972# 0.03755f
C33 a_13650_2532# a_8954_3092# 0.02084f
C34 a_258_852# a_258_1412# 0.00254f
C35 a_8954_2532# a_8954_3092# 0.45579f
C36 a_258_1972# a_258_2532# 0.00254f
C37 in[7] in[6] 0.0246f
C38 a_9226_292# a_8954_292# 0.02412f
C39 a_13650_1972# a_13650_2532# 0.00254f
C40 a_258_4212# in[6] 0.02244f
C41 a_4570_852# a_4570_1412# 0.03755f
C42 a_8954_1972# a_8954_2532# 0.45579f
C43 a_13650_1972# a_8954_2532# 0.02084f
C44 a_258_1972# in[2] 0.02244f
C45 a_258_3652# a_258_4212# 0.00254f
C46 a_258_4772# in[7] 0.02244f
C47 a_8954_1412# a_8954_1972# 0.45579f
C48 a_13650_4212# a_13650_3652# 0.00254f
C49 term in[0] 0.0246f
C50 a_258_4772# a_258_4212# 0.00254f
C51 a_13650_1412# a_8954_1972# 0.02084f
C52 a_13650_1412# a_13650_1972# 0.00254f
C53 a_258_2532# in[3] 0.02244f
C54 a_8954_4212# a_13650_3652# 0.02084f
C55 a_9226_4772# out 0.02948f
C56 term VSS 0.29859f
C57 in[0] VSS 0.27428f
C58 in[1] VSS 0.27428f
C59 in[2] VSS 0.27428f
C60 in[3] VSS 0.27428f
C61 in[4] VSS 0.27428f
C62 in[5] VSS 0.27428f
C63 in[6] VSS 0.27428f
C64 out VSS 2.2876f
C65 in[7] VSS 0.29859f
C66 a_9226_292# VSS 0.16679f
C67 a_4570_292# VSS 0.47443f
C68 a_258_292# VSS 0.1656f
C69 a_13650_852# VSS 0.1656f
C70 a_8954_292# VSS 0.83787f
C71 a_4570_852# VSS 0.43865f
C72 a_258_852# VSS 0.16242f
C73 a_13650_1412# VSS 0.16242f
C74 a_8954_1412# VSS 2.35976f
C75 a_4570_1412# VSS 0.43865f
C76 a_258_1412# VSS 0.16242f
C77 a_13650_1972# VSS 0.16242f
C78 a_8954_1972# VSS 2.03339f
C79 a_4570_1972# VSS 0.43865f
C80 a_258_1972# VSS 0.16242f
C81 a_13650_2532# VSS 0.16242f
C82 a_8954_2532# VSS 2.03339f
C83 a_4570_2532# VSS 0.43865f
C84 a_258_2532# VSS 0.16242f
C85 a_13650_3092# VSS 0.16242f
C86 a_8954_3092# VSS 2.03339f
C87 a_4570_3092# VSS 0.43865f
C88 a_258_3092# VSS 0.16242f
C89 a_13650_3652# VSS 0.16242f
C90 a_8954_3652# VSS 2.03339f
C91 a_4570_3652# VSS 0.43865f
C92 a_258_3652# VSS 0.16242f
C93 a_13650_4212# VSS 0.1656f
C94 a_8954_4212# VSS 2.03624f
C95 a_4570_4212# VSS 0.43865f
C96 a_258_4212# VSS 0.16242f
C97 a_9226_4772# VSS 0.16679f
C98 a_4570_4772# VSS 0.47443f
C99 a_258_4772# VSS 0.1656f
R_FLT0 a_13650_1412# VSS 1T
R_FLT1 a_13650_1972# VSS 1T
R_FLT2 a_13650_2532# VSS 1T
R_FLT3 a_13650_3092# VSS 1T
R_FLT4 a_13650_3652# VSS 1T
R_FLT5 a_13650_4212# VSS 1T
R_FLT6 a_13650_852# VSS 1T
R_FLT7 a_258_1412# VSS 1T
R_FLT8 a_258_1972# VSS 1T
R_FLT9 a_258_2532# VSS 1T
R_FLT10 a_258_292# VSS 1T
R_FLT11 a_258_3092# VSS 1T
R_FLT12 a_258_3652# VSS 1T
R_FLT13 a_258_4212# VSS 1T
R_FLT14 a_258_4772# VSS 1T
R_FLT15 a_258_852# VSS 1T
R_FLT16 a_9226_292# VSS 1T
R_FLT17 a_9226_4772# VSS 1T
.ends
