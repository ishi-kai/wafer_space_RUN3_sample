* NGSPICE file created from div3.ext - technology: gf180mcuD

.subckt dff_st_T1P m D cki VDD
X0 D cki m VDD pfet_03v3 ad=1.78p pd=8.89u as=1.78p ps=8.89u w=4u l=0.28u
.ends

.subckt dff_st_T2P m mf ckb VDD
X0 mf ckb m VDD pfet_03v3 ad=0.89p pd=4.89u as=0.89p ps=4.89u w=2u l=0.28u
.ends

.subckt inv_lo1_MN Y A VSS
X0 Y A VSS VSS nfet_03v3 ad=0.89p pd=4.89u as=0.89p ps=4.89u w=2u l=0.28u
.ends

.subckt inv_lo1_MP Y A VDD
X0 Y A VDD VDD pfet_03v3 ad=1.78p pd=8.89u as=1.78p ps=8.89u w=4u l=0.28u
.ends

.subckt inv_lo1 VDD A Y VSS
XXMN Y A VSS inv_lo1_MN
XXMP Y A VDD inv_lo1_MP
.ends

.subckt inv_dig_MN Y A VSS
X0 Y A VSS VSS nfet_03v3 ad=0.445p pd=2.89u as=0.445p ps=2.89u w=1u l=0.28u
.ends

.subckt inv_dig_MP Y A VDD
X0 Y A VDD VDD pfet_03v3 ad=0.89p pd=4.89u as=0.89p ps=4.89u w=2u l=0.28u
.ends

.subckt inv_dig VDD A Y VSS
XXMN Y A VSS inv_dig_MN
XXMP Y A VDD inv_dig_MP
.ends

.subckt dff_st_T4N sl QB ckb VSS
X0 QB ckb sl VSS nfet_03v3 ad=0.445p pd=2.89u as=0.445p ps=2.89u w=1u l=0.28u
.ends

.subckt dff_st_T3N sl mb cki VSS
X0 mb cki sl VSS nfet_03v3 ad=0.89p pd=4.89u as=0.89p ps=4.89u w=2u l=0.28u
.ends

.subckt dff_st_T2N m mf cki VSS
X0 mf cki m VSS nfet_03v3 ad=0.445p pd=2.89u as=0.445p ps=2.89u w=1u l=0.28u
.ends

.subckt dff_st_T4P sl QB cki VDD
X0 QB cki sl VDD pfet_03v3 ad=0.89p pd=4.89u as=0.89p ps=4.89u w=2u l=0.28u
.ends

.subckt dff_st_T3P sl mb ckb VDD
X0 mb ckb sl VDD pfet_03v3 ad=1.78p pd=8.89u as=1.78p ps=8.89u w=4u l=0.28u
.ends

.subckt dff_st_T1N m D ckb VSS
X0 D ckb m VSS nfet_03v3 ad=0.89p pd=4.89u as=0.89p ps=4.89u w=2u l=0.28u
.ends

.subckt dff_st VDD D CK Q QB VSS
XXT1P XM1/A D XCK2/Y VDD dff_st_T1P
XXT2P XM1/A XM2/Y XCK2/A VDD dff_st_T2P
XXS1 VDD XS1/A Q VSS inv_lo1
XXS2 VDD Q QB VSS inv_lo1
XXM1 VDD XM1/A XM2/A VSS inv_lo1
XXM2 VDD XM2/A XM2/Y VSS inv_dig
XXCK1 VDD CK XCK2/A VSS inv_lo1
XXCK2 VDD XCK2/A XCK2/Y VSS inv_lo1
XXT4N XS1/A QB XCK2/A VSS dff_st_T4N
XXT3N XS1/A XM2/A XCK2/Y VSS dff_st_T3N
XXT2N XM1/A XM2/Y XCK2/Y VSS dff_st_T2N
XXT4P XS1/A QB XCK2/Y VDD dff_st_T4P
XXT3P XS1/A XM2/A XCK2/A VDD dff_st_T3P
XXT1N XM1/A D XCK2/A VSS dff_st_T1N
.ends

.subckt nor2_MP1 n1 A VDD
X0 n1 A VDD VDD pfet_03v3 ad=1.78p pd=8.89u as=1.78p ps=8.89u w=4u l=0.28u
.ends

.subckt nor2_MP2 n1 Y B VDD
X0 Y B n1 VDD pfet_03v3 ad=1.78p pd=8.89u as=1.78p ps=8.89u w=4u l=0.28u
.ends

.subckt nor2_MN1 Y A VSS
X0 Y A VSS VSS nfet_03v3 ad=0.445p pd=2.89u as=0.445p ps=2.89u w=1u l=0.28u
.ends

.subckt nor2_MN2 Y B VSS
X0 Y B VSS VSS nfet_03v3 ad=0.445p pd=2.89u as=0.445p ps=2.89u w=1u l=0.28u
.ends

.subckt nor2 VDD A B Y VSS
XXMP1 XMP2/n1 A VDD nor2_MP1
XXMP2 XMP2/n1 Y B VDD nor2_MP2
XXMN1 Y A VSS nor2_MN1
XXMN2 Y B VSS nor2_MN2
.ends

.subckt div3 VSS VDD CK Q
XXF1 VDD XN/Y CK Q XF1/QB VSS dff_st
XXF2 VDD Q CK XN/B XF2/QB VSS dff_st
XXN VDD Q XN/B XN/Y VSS nor2
.ends
