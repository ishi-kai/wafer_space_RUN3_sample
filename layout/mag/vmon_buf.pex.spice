* NGSPICE file created from vmon_buf_flat.ext - technology: gf180mcuD

.subckt vmon_buf_flat VSS VDD IN NB OUT
X0 VSS NB a_2169_1460# VSS nfet_03v3 ad=3.56p pd=16.89u as=2.12p ps=8.53u w=8u l=2u
X1 OUT OUT a_2169_1460# VSS nfet_03v3 ad=2.12p pd=8.53u as=2.12p ps=8.53u w=8u l=1u
X2 a_2169_1460# IN a_1749_8069# VSS nfet_03v3 ad=2.12p pd=8.53u as=2.12p ps=8.53u w=8u l=1u
X3 a_2169_1460# NB VSS VSS nfet_03v3 ad=2.12p pd=8.53u as=3.56p ps=16.89u w=8u l=2u
X4 VDD a_1749_8069# a_1749_8069# VDD pfet_03v3 ad=1.06p pd=4.53u as=1.06p ps=4.53u w=4u l=2u
X5 VDD a_1749_8069# OUT VDD pfet_03v3 ad=1.78p pd=8.89u as=1.06p ps=4.53u w=4u l=2u
X6 a_1749_8069# a_1749_8069# VDD VDD pfet_03v3 ad=1.06p pd=4.53u as=1.78p ps=8.89u w=4u l=2u
X7 a_1749_8069# IN a_2169_1460# VSS nfet_03v3 ad=2.12p pd=8.53u as=3.56p ps=16.89u w=8u l=1u
X8 OUT a_1749_8069# VDD VDD pfet_03v3 ad=1.06p pd=4.53u as=1.06p ps=4.53u w=4u l=2u
X9 a_2169_1460# OUT OUT VSS nfet_03v3 ad=3.56p pd=16.89u as=2.12p ps=8.53u w=8u l=1u
C0 NB IN 0.05782f
C1 NB a_2169_1460# 0.56579f
C2 IN a_2824_1400# 0.02888f
C3 a_1220_7140# VDD 1.93295f
C4 a_2169_1460# a_2824_1400# 0.05868f
C5 OUT IN 0.01875f
C6 OUT a_2169_1460# 1.05685f
C7 a_1220_1400# IN 0.03073f
C8 a_1749_8069# a_3836_7140# 0.029f
C9 a_6116_1639# a_2169_1460# 0.17232f
C10 a_1749_8069# a_4500_1639# 0.04077f
C11 VDD NB 0.41144f
C12 IN a_4500_1639# 0.03657f
C13 OUT VDD 0.95498f
C14 a_2169_1460# a_4500_1639# 0.18873f
C15 OUT a_6116_1639# 0.05612f
C16 OUT a_3836_7140# 0.05698f
C17 a_3836_7140# VDD 1.92027f
C18 a_1749_8069# IN 0.48802f
C19 a_1749_8069# a_2169_1460# 0.55199f
C20 a_2169_1460# IN 0.50981f
C21 a_1749_8069# OUT 0.51421f
C22 a_1749_8069# VDD 5.51454f
C23 IN VSS 3.54391f
C24 NB VSS 5.74123f
C25 OUT VSS 5.91751f
C26 VDD VSS 33.137f
C27 a_6116_1639# VSS 2.11443f
C28 a_4500_1639# VSS 2.11443f
C29 a_2824_1400# VSS 3.59083f
C30 a_2169_1460# VSS 2.16497f ; **FLOATING
C31 a_1220_1400# VSS 3.60909f
C32 a_3836_7140# VSS 0.14314f
C33 a_1220_7140# VSS 0.14314f
C34 a_1749_8069# VSS 3.49484f ; **FLOATING
.ends
