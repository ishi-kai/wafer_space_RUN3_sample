* NGSPICE file created from if_chain_flat.ext - technology: gf180mcuD

.subckt if_chain_flat VSS VDD INP INN G1A G1B G2A G2B G3A G3B NB VTN OUTP OUTN
X0 a_4409_76080# VTN.t55 VSS VSS nfet_03v3 ad=2.12p pd=8.53u as=2.12p ps=8.53u w=8u l=2u
X1 VSS NB.t70 a_43680_10659.t10 VSS nfet_03v3 ad=2.12p pd=8.53u as=2.12p ps=8.53u w=8u l=2u
X2 VDD a_4409_66700.t22 a_3989_67569.t3 VDD pfet_03v3 ad=1.06p pd=4.53u as=1.06p ps=4.53u w=4u l=2u
X3 a_4409_62080.t11 a_4409_62080.t10 VDD VDD pfet_03v3 ad=1.06p pd=4.53u as=1.78p ps=8.89u w=4u l=2u
X4 a_35349_76080# VTN.t1 VSS VSS nfet_03v3 ad=2.12p pd=8.53u as=2.12p ps=8.53u w=8u l=2u
X5 VDD a_11985_10449.t7 a_12117_10659.t15 VDD pfet_03v3 ad=1.59p pd=6.53u as=1.59p ps=6.53u w=6u l=0.56u
X6 a_26880_10659.t20 NB.t41 VSS VSS nfet_03v3 ad=2.12p pd=8.53u as=2.12p ps=8.53u w=8u l=2u
X7 a_3849_72329.t0 a_3989_67569.t25 a_6433_76080# VSS nfet_03v3 ad=0.795p pd=3.53u as=1.335p ps=6.89u w=3u l=1u
X8 VDD a_4409_66700.t26 a_3989_67569.t0 VDD pfet_03v3 ad=1.06p pd=4.53u as=1.06p ps=4.53u w=4u l=2u
X9 VSS VTN.t18 a_37373_76080# VSS nfet_03v3 ad=2.12p pd=8.53u as=2.12p ps=8.53u w=8u l=2u
X10 VDD a_34929_67569.t7 a_34929_67569.t6 VDD pfet_03v3 ad=1.06p pd=4.53u as=1.06p ps=4.53u w=4u l=2u
X11 VDD a_1545_1460# a_1601_10659.t12 VDD pfet_03v3 ad=1.59p pd=6.53u as=1.59p ps=6.53u w=6u l=0.56u
X12 a_3225_5800.t2 G2A.t2 a_3080_5800.t9 VDD pfet_03v3 ad=1.78p pd=8.89u as=1.78p ps=8.89u w=4u l=0.28u
X13 a_25660_18046# a_26500_15924# VSS ppolyf_u_1k r_width=1u r_length=10u
X14 VSS NB.t112 a_39480_10659.t4 VSS nfet_03v3 ad=2.12p pd=8.53u as=2.12p ps=8.53u w=8u l=2u
X15 a_15300_18046# a_14460_15924# VSS ppolyf_u_1k r_width=1u r_length=10u
X16 a_4409_66700.t12 a_3849_72329.t27 a_5421_76080# VSS nfet_03v3 ad=0.795p pd=3.53u as=1.335p ps=6.89u w=3u l=1u
X17 VDD a_10785_5800.t4 a_10640_5800.t4 VDD pfet_03v3 ad=2.67p pd=12.89u as=1.59p ps=6.53u w=6u l=0.56u
X18 VDD a_2037_10659.t5 a_2037_10659.t4 VDD pfet_03v3 ad=1.59p pd=6.53u as=1.59p ps=6.53u w=6u l=0.56u
X19 VSS VTN.t32 a_4409_76080# VSS nfet_03v3 ad=3.56p pd=16.89u as=2.12p ps=8.53u w=8u l=2u
X20 a_39480_10659.t0 NB.t153 VSS VSS nfet_03v3 ad=2.12p pd=8.53u as=2.12p ps=8.53u w=8u l=2u
X21 a_31080_10659.t7 NB.t83 VSS VSS nfet_03v3 ad=2.12p pd=8.53u as=2.12p ps=8.53u w=8u l=2u
X22 a_1601_15740.t1 a_1400_1460.t86 VDD VDD pfet_03v3 ad=1.59p pd=6.53u as=2.67p ps=12.89u w=6u l=0.56u
X23 VDD a_1469_11989.t4 a_1601_10659.t0 VDD pfet_03v3 ad=1.59p pd=6.53u as=1.59p ps=6.53u w=6u l=0.56u
X24 VSS VTN.t14 a_34720_71559# VSS nfet_03v3 ad=2.12p pd=8.53u as=2.12p ps=8.53u w=8u l=2u
X25 a_50020_18046# a_50860_15924# VSS ppolyf_u_1k r_width=1u r_length=10u
X26 VSS NB.t44 a_35280_10659.t13 VSS nfet_03v3 ad=2.12p pd=8.53u as=2.12p ps=8.53u w=8u l=2u
X27 a_1427_6669.t1 G2A.t4 VDD VDD pfet_03v3 ad=1.78p pd=8.89u as=1.78p ps=8.89u w=4u l=1u
X28 a_4409_66700.t4 a_4409_66700.t3 VDD VDD pfet_03v3 ad=1.06p pd=4.53u as=1.06p ps=4.53u w=4u l=2u
X29 a_57160_18046# a_44073_10449# VSS ppolyf_u_1k r_width=1u r_length=10u
X30 VSS NB.t56 a_39480_10659.t10 VSS nfet_03v3 ad=2.12p pd=8.53u as=2.12p ps=8.53u w=8u l=2u
X31 VSS NB.t132 a_31080_10659.t2 VSS nfet_03v3 ad=2.12p pd=8.53u as=2.12p ps=8.53u w=8u l=2u
X32 a_43680_10659.t11 NB.t61 VSS VSS nfet_03v3 ad=2.12p pd=8.53u as=2.12p ps=8.53u w=8u l=2u
X33 a_10640_5800.t14 a_1545_5800.t7 VDD VDD pfet_03v3 ad=1.59p pd=6.53u as=2.67p ps=12.89u w=6u l=0.56u
X34 a_2037_15740.t0 a_1400_1460.t42 VDD VDD pfet_03v3 ad=1.59p pd=6.53u as=1.59p ps=6.53u w=6u l=0.56u
X35 VDD a_1400_1460.t83 a_2037_15740.t4 VDD pfet_03v3 ad=1.59p pd=6.53u as=1.59p ps=6.53u w=6u l=0.56u
X36 a_10640_5800.t16 a_26500_15924# a_31080_10659.t17 VSS nfet_03v3 ad=1.325p pd=5.53u as=1.325p ps=5.53u w=5u l=0.28u
X37 a_2037_15740.t7 a_2037_15740.t6 VDD VDD pfet_03v3 ad=1.59p pd=6.53u as=1.59p ps=6.53u w=6u l=0.56u
X38 a_30980_18046# a_30140_15924# VSS ppolyf_u_1k r_width=1u r_length=10u
X39 a_34929_67569.t12 a_34929_67569.t11 VDD VDD pfet_03v3 ad=1.06p pd=4.53u as=1.78p ps=8.89u w=4u l=2u
X40 VSS NB.t86 a_39480_10659.t7 VSS nfet_03v3 ad=2.12p pd=8.53u as=2.12p ps=8.53u w=8u l=2u
X41 a_34789_72329.t0 a_34929_67569.t24 a_37373_76080# VSS nfet_03v3 ad=0.795p pd=3.53u as=1.335p ps=6.89u w=3u l=1u
X42 VDD a_35349_66700.t27 a_34929_67569.t0 VDD pfet_03v3 ad=1.06p pd=4.53u as=1.06p ps=4.53u w=4u l=2u
X43 a_34789_72329.t5 a_35349_62080.t7 VDD VDD pfet_03v3 ad=1.06p pd=4.53u as=1.78p ps=8.89u w=4u l=2u
X44 VDD a_11549_11989.t9 a_11681_10659.t3 VDD pfet_03v3 ad=1.59p pd=6.53u as=1.59p ps=6.53u w=6u l=0.56u
X45 VDD a_3849_72329.t1 a_3849_72329.t11 VDD pfet_03v3 ad=1.78p pd=8.89u as=1.06p ps=4.53u w=4u l=2u
X46 VSS NB.t98 a_43680_10659.t8 VSS nfet_03v3 ad=2.12p pd=8.53u as=2.12p ps=8.53u w=8u l=2u
X47 VDD a_3225_5800.t6 a_3080_5800.t16 VDD pfet_03v3 ad=1.59p pd=6.53u as=1.59p ps=6.53u w=6u l=0.56u
X48 VDD a_1400_1460.t39 a_1601_15740.t2 VDD pfet_03v3 ad=2.67p pd=12.89u as=1.59p ps=6.53u w=6u l=0.56u
X49 a_39480_10659.t5 NB.t103 VSS VSS nfet_03v3 ad=2.12p pd=8.53u as=2.12p ps=8.53u w=8u l=2u
X50 VSS NB.t160 a_1400_1460.t32 VSS nfet_03v3 ad=3.56p pd=16.89u as=2.12p ps=8.53u w=8u l=2u
X51 a_35280_10659.t6 NB.t115 VSS VSS nfet_03v3 ad=2.12p pd=8.53u as=2.12p ps=8.53u w=8u l=2u
X52 a_3080_5800.t10 a_14145_5800.t4 VDD VDD pfet_03v3 ad=1.59p pd=6.53u as=1.59p ps=6.53u w=6u l=0.56u
X53 a_43680_10659.t4 NB.t139 VSS VSS nfet_03v3 ad=2.12p pd=8.53u as=2.12p ps=8.53u w=8u l=2u
X54 a_50440_18046# a_51280_15924# VSS ppolyf_u_1k r_width=1u r_length=10u
X55 a_40080_18046# a_1400_1460.t30 VSS ppolyf_u_1k r_width=1u r_length=10u
X56 VDD a_3989_67569.t13 a_3989_67569.t14 VDD pfet_03v3 ad=1.06p pd=4.53u as=1.06p ps=4.53u w=4u l=2u
X57 a_10785_5800.t1 a_6869_5800.t5 a_1400_1460.t2 VDD pfet_03v3 ad=1.78p pd=8.89u as=1.78p ps=8.89u w=4u l=0.28u
X58 a_11681_10659.t4 a_11549_11989.t8 VDD VDD pfet_03v3 ad=1.59p pd=6.53u as=1.59p ps=6.53u w=6u l=0.56u
X59 a_4409_62080.t16 a_4409_62080.t1 VDD VDD pfet_03v3 ad=1.06p pd=4.53u as=1.78p ps=8.89u w=4u l=2u
X60 a_1601_10659.t12 a_1545_1460# VDD VDD pfet_03v3 ad=1.59p pd=6.53u as=1.59p ps=6.53u w=6u l=0.56u
X61 a_34929_67569.t4 a_35349_62080.t26 a_36361_76080# VSS nfet_03v3 ad=0.795p pd=3.53u as=0.795p ps=3.53u w=3u l=1u
X62 OUTP.t8 a_1400_1460.t80 VDD VDD pfet_03v3 ad=1.59p pd=6.53u as=1.59p ps=6.53u w=6u l=0.56u
X63 a_3225_1460# a_3107_2049.t4 a_1400_1460.t36 VDD pfet_03v3 ad=1.78p pd=8.89u as=1.78p ps=8.89u w=4u l=0.28u
X64 a_39873_10449# a_1601_10659.t18 cap_mim_2f0_m4m5_noshield c_width=52.2u c_length=52.2u
X65 a_35280_10659.t4 NB.t135 VSS VSS nfet_03v3 ad=2.12p pd=8.53u as=2.12p ps=8.53u w=8u l=2u
X66 a_11985_10449.t1 a_45947_6389# a_1400_1460.t8 VDD pfet_03v3 ad=1.78p pd=8.89u as=1.78p ps=8.89u w=4u l=0.28u
X67 a_34929_67569.t1 a_35349_66700.t22 VDD VDD pfet_03v3 ad=1.06p pd=4.53u as=1.06p ps=4.53u w=4u l=2u
X68 a_34789_72329.t3 a_35349_62080.t24 VDD VDD pfet_03v3 ad=1.06p pd=4.53u as=1.78p ps=8.89u w=4u l=2u
X69 a_26880_10659.t22 NB.t29 VSS VSS nfet_03v3 ad=2.12p pd=8.53u as=2.12p ps=8.53u w=8u l=2u
X70 VSS NB.t118 a_26880_10659.t13 VSS nfet_03v3 ad=2.12p pd=8.53u as=2.12p ps=8.53u w=8u l=2u
X71 a_5421_76080# VTN.t43 VSS VSS nfet_03v3 ad=2.12p pd=8.53u as=2.12p ps=8.53u w=8u l=2u
X72 VSS VTN.t48 a_3780_71559# VSS nfet_03v3 ad=2.12p pd=8.53u as=2.12p ps=8.53u w=8u l=2u
X73 a_31080_10659.t10 NB.t53 VSS VSS nfet_03v3 ad=2.12p pd=8.53u as=2.12p ps=8.53u w=8u l=2u
X74 a_6869_5800.t1 G2B.t4 VDD VDD pfet_03v3 ad=1.78p pd=8.89u as=1.78p ps=8.89u w=4u l=1u
X75 a_26880_10659.t9 NB.t159 VSS VSS nfet_03v3 ad=2.12p pd=8.53u as=3.56p ps=16.89u w=8u l=2u
X76 VSS NB.t8 a_43680_10659.t17 VSS nfet_03v3 ad=2.12p pd=8.53u as=2.12p ps=8.53u w=8u l=2u
X77 VDD a_1400_1460.t77 OUTP.t15 VDD pfet_03v3 ad=1.59p pd=6.53u as=1.59p ps=6.53u w=6u l=0.56u
X78 VSS NB.t20 a_43680_10659.t15 VSS nfet_03v3 ad=2.12p pd=8.53u as=2.12p ps=8.53u w=8u l=2u
X79 a_3849_72329.t7 a_3849_72329.t6 VDD VDD pfet_03v3 ad=1.06p pd=4.53u as=1.06p ps=4.53u w=4u l=2u
X80 VDD a_34929_67569.t11 a_34929_67569.t14 VDD pfet_03v3 ad=1.78p pd=8.89u as=1.06p ps=4.53u w=4u l=2u
X81 a_35280_10659.t15 NB.t25 VSS VSS nfet_03v3 ad=2.12p pd=8.53u as=2.12p ps=8.53u w=8u l=2u
X82 a_4409_62080.t4 a_3849_72329.t23 VDD VDD pfet_03v3 ad=1.06p pd=4.53u as=1.06p ps=4.53u w=4u l=2u
X83 VDD a_1601_15740.t6 a_1601_15740.t7 VDD pfet_03v3 ad=1.59p pd=6.53u as=1.59p ps=6.53u w=6u l=0.56u
X84 a_3780_71559# VTN.t39 VSS VSS nfet_03v3 ad=2.12p pd=8.53u as=2.12p ps=8.53u w=8u l=2u
X85 a_31080_10659.t12 NB.t37 VSS VSS nfet_03v3 ad=2.12p pd=8.53u as=2.12p ps=8.53u w=8u l=2u
X86 a_2037_15740.t13 a_39873_10449# a_39480_10659.t17 VSS nfet_03v3 ad=1.325p pd=5.53u as=1.325p ps=5.53u w=5u l=0.28u
X87 a_10785_5800.t0 a_6869_5800.t3 a_10640_5800.t0 VSS nfet_03v3 ad=0.89p pd=4.89u as=0.89p ps=4.89u w=2u l=0.28u
X88 a_35673_10449# a_34789_72329.t7 cap_mim_2f0_m4m5_noshield c_width=52.2u c_length=52.2u
X89 a_3080_5800.t12 a_14145_5800.t4 VDD VDD pfet_03v3 ad=1.59p pd=6.53u as=1.59p ps=6.53u w=6u l=0.56u
X90 a_11681_10659.t3 a_11549_11989.t10 VDD VDD pfet_03v3 ad=1.59p pd=6.53u as=2.67p ps=12.89u w=6u l=0.56u
X91 VDD a_35349_66700.t9 a_35349_66700.t8 VDD pfet_03v3 ad=1.06p pd=4.53u as=1.06p ps=4.53u w=4u l=2u
X92 a_3080_5800.t16 a_3225_5800.t7 VDD VDD pfet_03v3 ad=1.59p pd=6.53u as=1.59p ps=6.53u w=6u l=0.56u
X93 a_29300_18046# a_1400_1460.t4 VSS ppolyf_u_1k r_width=1u r_length=10u
X94 a_5421_76080# VTN.t53 VSS VSS nfet_03v3 ad=2.12p pd=8.53u as=2.12p ps=8.53u w=8u l=2u
X95 VSS NB.t114 a_35280_10659.t6 VSS nfet_03v3 ad=2.12p pd=8.53u as=2.12p ps=8.53u w=8u l=2u
X96 VSS NB.t68 a_26880_10659.t18 VSS nfet_03v3 ad=2.12p pd=8.53u as=2.12p ps=8.53u w=8u l=2u
X97 a_12117_10659.t17 a_11985_10449.t4 VDD VDD pfet_03v3 ad=1.59p pd=6.53u as=1.59p ps=6.53u w=6u l=0.56u
X98 VDD a_4409_66700.t20 a_3989_67569.t1 VDD pfet_03v3 ad=1.78p pd=8.89u as=1.06p ps=4.53u w=4u l=2u
X99 a_1545_1460# a_3107_2049.t5 a_1400_1460.t37 VDD pfet_03v3 ad=1.78p pd=8.89u as=1.78p ps=8.89u w=4u l=0.28u
X100 VDD a_11985_10449.t9 a_12117_10659.t14 VDD pfet_03v3 ad=1.59p pd=6.53u as=1.59p ps=6.53u w=6u l=0.56u
X101 VSS VTN.t16 a_34720_71559# VSS nfet_03v3 ad=2.12p pd=8.53u as=2.12p ps=8.53u w=8u l=2u
X102 a_34720_71559# a_35349_62080.t7 a_35349_62080.t7 VSS nfet_03v3 ad=1.335p pd=6.89u as=0.795p ps=3.53u w=3u l=1u
X103 VDD a_34929_67569.t10 a_34929_67569.t9 VDD pfet_03v3 ad=1.78p pd=8.89u as=1.06p ps=4.53u w=4u l=2u
X104 a_39345_5800# G1A.t1 a_1400_1460.t15 VSS nfet_03v3 ad=0.89p pd=4.89u as=0.89p ps=4.89u w=2u l=0.28u
X105 a_46800_18046# a_45960_15924# VSS ppolyf_u_1k r_width=1u r_length=10u
X106 a_3849_72329.t1 a_3849_72329.t1 a_3780_71559# VSS nfet_03v3 ad=0.795p pd=3.53u as=1.335p ps=6.89u w=3u l=1u
X107 a_34760_18046# a_35600_15924# VSS ppolyf_u_1k r_width=1u r_length=10u
X108 a_24400_18046# a_23560_15924# VSS ppolyf_u_1k r_width=1u r_length=10u
X109 a_12360_18046# a_13200_15924# VSS ppolyf_u_1k r_width=1u r_length=10u
X110 VSS NB.t134 a_35280_10659.t4 VSS nfet_03v3 ad=2.12p pd=8.53u as=2.12p ps=8.53u w=8u l=2u
X111 VSS NB.t110 a_43680_10659.t6 VSS nfet_03v3 ad=2.12p pd=8.53u as=2.12p ps=8.53u w=8u l=2u
X112 a_10785_5800.t3 G2B.t1 a_1400_1460.t19 VSS nfet_03v3 ad=0.89p pd=4.89u as=0.89p ps=4.89u w=2u l=0.28u
X113 VDD a_1400_1460.t81 OUTN.t6 VDD pfet_03v3 ad=1.59p pd=6.53u as=1.59p ps=6.53u w=6u l=0.56u
X114 a_12117_10659.t12 a_42705_5800# VDD VDD pfet_03v3 ad=1.59p pd=6.53u as=1.59p ps=6.53u w=6u l=0.56u
X115 a_26880_10659.t16 NB.t81 VSS VSS nfet_03v3 ad=2.12p pd=8.53u as=2.12p ps=8.53u w=8u l=2u
X116 OUTP.t9 a_44073_10449# a_43680_10659.t0 VSS nfet_03v3 ad=1.325p pd=5.53u as=1.325p ps=5.53u w=5u l=0.28u
X117 a_43680_10659.t2 NB.t151 VSS VSS nfet_03v3 ad=2.12p pd=8.53u as=2.12p ps=8.53u w=8u l=2u
X118 VDD a_1400_1460.t69 OUTP.t13 VDD pfet_03v3 ad=1.59p pd=6.53u as=1.59p ps=6.53u w=6u l=0.56u
X119 a_26080_18046# a_26920_15924# VSS ppolyf_u_1k r_width=1u r_length=10u
X120 VSS VTN.t12 a_37373_76080# VSS nfet_03v3 ad=2.12p pd=8.53u as=2.12p ps=8.53u w=8u l=2u
X121 a_35349_62080.t7 a_34789_72329.t30 VDD VDD pfet_03v3 ad=1.06p pd=4.53u as=1.06p ps=4.53u w=4u l=2u
X122 a_15720_18046# a_14880_15924# VSS ppolyf_u_1k r_width=1u r_length=10u
X123 VDD a_35349_62080.t7 a_35349_62080.t8 VDD pfet_03v3 ad=1.06p pd=4.53u as=1.06p ps=4.53u w=4u l=2u
X124 a_3225_5800.t1 a_1427_6669.t2 a_3080_5800.t7 VSS nfet_03v3 ad=0.89p pd=4.89u as=0.89p ps=4.89u w=2u l=0.28u
X125 a_34789_72329.t24 a_35349_62080.t18 cap_mim_2f0_m4m5_noshield c_width=25.98u c_length=25.98u
X126 VDD a_3225_5800.t4 a_3080_5800.t17 VDD pfet_03v3 ad=1.59p pd=6.53u as=1.59p ps=6.53u w=6u l=0.56u
X127 OUTP.t15 a_1400_1460.t78 VDD VDD pfet_03v3 ad=1.59p pd=6.53u as=1.59p ps=6.53u w=6u l=0.56u
X128 a_39227_6389# G1A.t3 VDD VDD pfet_03v3 ad=1.78p pd=8.89u as=1.78p ps=8.89u w=4u l=1u
X129 a_11549_11989.t2 G1B.t3 a_11681_10659.t17 VDD pfet_03v3 ad=1.78p pd=8.89u as=1.78p ps=8.89u w=4u l=0.28u
X130 a_36361_76080# VTN.t29 VSS VSS nfet_03v3 ad=2.12p pd=8.53u as=2.12p ps=8.53u w=8u l=2u
X131 VSS NB.t130 a_26880_10659.t11 VSS nfet_03v3 ad=2.12p pd=8.53u as=2.12p ps=8.53u w=8u l=2u
X132 VDD a_1601_15740.t6 a_1601_15740.t9 VDD pfet_03v3 ad=2.67p pd=12.89u as=1.59p ps=6.53u w=6u l=0.56u
X133 a_31080_10659.t1 NB.t147 VSS VSS nfet_03v3 ad=2.12p pd=8.53u as=2.12p ps=8.53u w=8u l=2u
X134 a_12117_10659.t15 a_11985_10449.t8 VDD VDD pfet_03v3 ad=1.59p pd=6.53u as=1.59p ps=6.53u w=6u l=0.56u
X135 a_46380_18046# a_39549_11849# VSS ppolyf_u_1k r_width=1u r_length=10u
X136 VDD a_35349_66700.t25 a_34929_67569.t3 VDD pfet_03v3 ad=1.78p pd=8.89u as=1.06p ps=4.53u w=4u l=2u
X137 VSS NB.t84 a_35280_10659.t9 VSS nfet_03v3 ad=2.12p pd=8.53u as=2.12p ps=8.53u w=8u l=2u
X138 a_36020_18046# a_35180_15924# VSS ppolyf_u_1k r_width=1u r_length=10u
X139 a_35349_76080# a_10640_5800.t18 a_34929_67569.t2 VSS nfet_03v3 ad=1.335p pd=6.89u as=0.795p ps=3.53u w=3u l=1u
X140 a_3989_67569.t0 a_4409_66700.t27 VDD VDD pfet_03v3 ad=1.06p pd=4.53u as=1.78p ps=8.89u w=4u l=2u
X141 VDD a_3849_72329.t1 a_4409_62080.t1 VDD pfet_03v3 ad=1.06p pd=4.53u as=1.06p ps=4.53u w=4u l=2u
X142 VSS NB.t96 a_39480_10659.t6 VSS nfet_03v3 ad=2.12p pd=8.53u as=2.12p ps=8.53u w=8u l=2u
X143 VDD a_14145_5800.t4 a_3080_5800.t11 VDD pfet_03v3 ad=1.59p pd=6.53u as=1.59p ps=6.53u w=6u l=0.56u
X144 a_43680_10659.t7 NB.t101 VSS VSS nfet_03v3 ad=2.12p pd=8.53u as=2.12p ps=8.53u w=8u l=2u
X145 a_5421_76080# a_4409_62080.t25 a_3989_67569.t18 VSS nfet_03v3 ad=1.335p pd=6.89u as=0.795p ps=3.53u w=3u l=1u
X146 VSS VTN.t62 a_4409_76080# VSS nfet_03v3 ad=2.12p pd=8.53u as=2.12p ps=8.53u w=8u l=2u
X147 VDD a_11985_10449.t5 a_12117_10659.t16 VDD pfet_03v3 ad=1.59p pd=6.53u as=1.59p ps=6.53u w=6u l=0.56u
X148 VSS NB.t32 a_39480_10659.t12 VSS nfet_03v3 ad=2.12p pd=8.53u as=2.12p ps=8.53u w=8u l=2u
X149 a_15300_18046# a_16140_15924# VSS ppolyf_u_1k r_width=1u r_length=10u
X150 a_34929_67569.t1 a_35349_66700.t24 VDD VDD pfet_03v3 ad=1.06p pd=4.53u as=1.78p ps=8.89u w=4u l=2u
X151 VDD a_35349_62080.t3 a_35349_62080.t2 VDD pfet_03v3 ad=1.06p pd=4.53u as=1.06p ps=4.53u w=4u l=2u
X152 VDD a_4409_66700.t6 a_4409_66700.t9 VDD pfet_03v3 ad=1.78p pd=8.89u as=1.06p ps=4.53u w=4u l=2u
X153 VDD a_3989_67569.t13 a_3989_67569.t16 VDD pfet_03v3 ad=1.78p pd=8.89u as=1.06p ps=4.53u w=4u l=2u
X154 a_34789_72329.t19 a_34789_72329.t18 VDD VDD pfet_03v3 ad=1.06p pd=4.53u as=1.06p ps=4.53u w=4u l=2u
X155 a_12117_10659.t14 a_11985_10449.t10 VDD VDD pfet_03v3 ad=1.59p pd=6.53u as=1.59p ps=6.53u w=6u l=0.56u
X156 a_6433_76080# VTN.t51 VSS VSS nfet_03v3 ad=2.12p pd=8.53u as=2.12p ps=8.53u w=8u l=2u
X157 a_35349_62080.t7 a_35349_62080.t7 a_34720_71559# VSS nfet_03v3 ad=0.795p pd=3.53u as=0.795p ps=3.53u w=3u l=1u
X158 a_31080_10659.t15 NB.t3 VSS VSS nfet_03v3 ad=2.12p pd=8.53u as=2.12p ps=8.53u w=8u l=2u
X159 a_4409_66700.t11 a_12117_10659.t19 a_4409_76080# VSS nfet_03v3 ad=0.795p pd=3.53u as=1.335p ps=6.89u w=3u l=1u
X160 VDD a_1400_1460.t75 OUTN.t15 VDD pfet_03v3 ad=1.59p pd=6.53u as=1.59p ps=6.53u w=6u l=0.56u
X161 a_2037_15740.t4 a_1400_1460.t84 VDD VDD pfet_03v3 ad=1.59p pd=6.53u as=1.59p ps=6.53u w=6u l=0.56u
X162 a_3849_72329.t4 a_3849_72329.t3 VDD VDD pfet_03v3 ad=1.06p pd=4.53u as=1.78p ps=8.89u w=4u l=2u
X163 VDD a_39345_5800# a_11681_10659.t13 VDD pfet_03v3 ad=1.59p pd=6.53u as=1.59p ps=6.53u w=6u l=0.56u
X164 a_9000_18046# a_1400_1460.t21 VSS ppolyf_u_1k r_width=1u r_length=10u
X165 a_43680_10659.t1 a_43749_11849# OUTN.t1 VSS nfet_03v3 ad=2.225p pd=10.89u as=1.325p ps=5.53u w=5u l=0.28u
X166 a_3849_72329.t20 a_4409_62080.t1 VDD VDD pfet_03v3 ad=1.06p pd=4.53u as=1.06p ps=4.53u w=4u l=2u
X167 a_4409_62080.t5 a_3849_72329.t25 VDD VDD pfet_03v3 ad=1.06p pd=4.53u as=1.78p ps=8.89u w=4u l=2u
X168 a_1601_15740.t0 a_1400_1460.t72 VDD VDD pfet_03v3 ad=1.59p pd=6.53u as=1.59p ps=6.53u w=6u l=0.56u
X169 a_3107_2049.t0 G3B.t5 VSS VSS nfet_03v3 ad=1.78p pd=8.89u as=1.78p ps=8.89u w=4u l=1u
X170 a_37373_76080# a_35349_66700.t29 a_35349_62080.t0 VSS nfet_03v3 ad=1.335p pd=6.89u as=0.795p ps=3.53u w=3u l=1u
X171 VDD a_3989_67569.t22 a_4409_66700.t15 VDD pfet_03v3 ad=1.06p pd=4.53u as=1.06p ps=4.53u w=4u l=2u
X172 a_26880_10659.t19 NB.t51 VSS VSS nfet_03v3 ad=2.12p pd=8.53u as=2.12p ps=8.53u w=8u l=2u
X173 VSS NB.t6 a_39480_10659.t15 VSS nfet_03v3 ad=2.12p pd=8.53u as=2.12p ps=8.53u w=8u l=2u
X174 VDD a_1400_1460.t79 OUTP.t8 VDD pfet_03v3 ad=1.59p pd=6.53u as=1.59p ps=6.53u w=6u l=0.56u
X175 VSS NB.t18 a_43680_10659.t16 VSS nfet_03v3 ad=2.12p pd=8.53u as=2.12p ps=8.53u w=8u l=2u
X176 a_1601_15740.t9 a_1601_15740.t6 VDD VDD pfet_03v3 ad=1.59p pd=6.53u as=1.59p ps=6.53u w=6u l=0.56u
X177 a_12117_10659.t13 a_42705_5800# VDD VDD pfet_03v3 ad=1.59p pd=6.53u as=1.59p ps=6.53u w=6u l=0.56u
X178 a_39480_10659.t13 NB.t23 VSS VSS nfet_03v3 ad=2.12p pd=8.53u as=2.12p ps=8.53u w=8u l=2u
X179 VDD a_10785_5800.t10 a_10640_5800.t1 VDD pfet_03v3 ad=1.59p pd=6.53u as=1.59p ps=6.53u w=6u l=0.56u
X180 a_2037_15740.t9 a_2037_15740.t6 VDD VDD pfet_03v3 ad=1.59p pd=6.53u as=1.59p ps=6.53u w=6u l=0.56u
X181 a_35280_10659.t14 NB.t35 VSS VSS nfet_03v3 ad=2.12p pd=8.53u as=2.12p ps=8.53u w=8u l=2u
X182 a_6433_76080# VTN.t37 VSS VSS nfet_03v3 ad=2.12p pd=8.53u as=2.12p ps=8.53u w=8u l=2u
X183 VSS NB.t42 a_31080_10659.t11 VSS nfet_03v3 ad=2.12p pd=8.53u as=2.12p ps=8.53u w=8u l=2u
X184 a_43680_10659.t0 a_43749_11849# OUTN.t4 VSS nfet_03v3 ad=1.325p pd=5.53u as=1.325p ps=5.53u w=5u l=0.28u
X185 VDD a_14145_5800.t4 a_3080_5800.t13 VDD pfet_03v3 ad=1.59p pd=6.53u as=1.59p ps=6.53u w=6u l=0.56u
X186 VDD a_11549_11989.t7 a_11681_10659.t4 VDD pfet_03v3 ad=1.59p pd=6.53u as=1.59p ps=6.53u w=6u l=0.56u
X187 a_31080_10659.t6 NB.t93 VSS VSS nfet_03v3 ad=2.12p pd=8.53u as=2.12p ps=8.53u w=8u l=2u
X188 a_37373_76080# VTN.t19 VSS VSS nfet_03v3 ad=2.12p pd=8.53u as=2.12p ps=8.53u w=8u l=2u
X189 a_39480_10659.t11 NB.t47 VSS VSS nfet_03v3 ad=2.12p pd=8.53u as=2.12p ps=8.53u w=8u l=2u
X190 a_34929_67569.t2 a_10640_5800.t19 a_35349_76080# VSS nfet_03v3 ad=0.795p pd=3.53u as=0.795p ps=3.53u w=3u l=1u
X191 VDD a_35349_66700.t12 a_35349_66700.t11 VDD pfet_03v3 ad=1.78p pd=8.89u as=1.06p ps=4.53u w=4u l=2u
X192 a_16140_15924# INP.t0 cap_mim_2f0_m4m5_noshield c_width=52.2u c_length=52.2u
X193 a_39480_10659.t17 a_39549_11849# a_1601_15740.t13 VSS nfet_03v3 ad=1.325p pd=5.53u as=1.325p ps=5.53u w=5u l=0.28u
X194 a_3080_5800.t11 a_14145_5800.t4 VDD VDD pfet_03v3 ad=1.59p pd=6.53u as=1.59p ps=6.53u w=6u l=0.56u
X195 a_10640_5800.t2 a_10785_5800.t9 VDD VDD pfet_03v3 ad=1.59p pd=6.53u as=1.59p ps=6.53u w=6u l=0.56u
X196 a_3849_72329.t18 a_4409_62080.t22 VDD VDD pfet_03v3 ad=1.06p pd=4.53u as=1.06p ps=4.53u w=4u l=2u
X197 VSS NB.t66 a_31080_10659.t9 VSS nfet_03v3 ad=2.12p pd=8.53u as=2.12p ps=8.53u w=8u l=2u
X198 OUTP.t11 a_44073_10449# a_43680_10659.t0 VSS nfet_03v3 ad=1.325p pd=5.53u as=1.325p ps=5.53u w=5u l=0.28u
X199 a_12117_10659.t16 a_11985_10449.t6 VDD VDD pfet_03v3 ad=1.59p pd=6.53u as=1.59p ps=6.53u w=6u l=0.56u
X200 a_14145_5800.t0 a_6869_5800.t4 a_1400_1460.t3 VDD pfet_03v3 ad=1.78p pd=8.89u as=1.78p ps=8.89u w=4u l=0.28u
X201 a_35349_66700.t17 a_35349_66700.t16 VDD VDD pfet_03v3 ad=1.06p pd=4.53u as=1.06p ps=4.53u w=4u l=2u
X202 VSS NB.t38 a_26880_10659.t21 VSS nfet_03v3 ad=2.12p pd=8.53u as=2.12p ps=8.53u w=8u l=2u
X203 a_29720_18046# a_1400_1460.t6 VSS ppolyf_u_1k r_width=1u r_length=10u
X204 VDD a_34929_67569.t21 a_35349_66700.t3 VDD pfet_03v3 ad=1.06p pd=4.53u as=1.06p ps=4.53u w=4u l=2u
X205 a_35349_62080.t7 a_34789_72329.t32 VDD VDD pfet_03v3 ad=1.06p pd=4.53u as=1.78p ps=8.89u w=4u l=2u
X206 a_55060_18046# a_55900_15924# VSS ppolyf_u_1k r_width=1u r_length=10u
X207 OUTN.t15 a_1400_1460.t76 VDD VDD pfet_03v3 ad=1.59p pd=6.53u as=1.59p ps=6.53u w=6u l=0.56u
X208 a_44700_18046# a_43860_15924# VSS ppolyf_u_1k r_width=1u r_length=10u
X209 a_32660_18046# a_33500_15924# VSS ppolyf_u_1k r_width=1u r_length=10u
X210 VSS NB.t108 a_26880_10659.t14 VSS nfet_03v3 ad=2.12p pd=8.53u as=2.12p ps=8.53u w=8u l=2u
X211 VDD a_39345_5800# a_11681_10659.t14 VDD pfet_03v3 ad=2.67p pd=12.89u as=1.59p ps=6.53u w=6u l=0.56u
X212 a_22300_18046# a_21460_15924# VSS ppolyf_u_1k r_width=1u r_length=10u
X213 a_10260_18046# a_11100_15924# VSS ppolyf_u_1k r_width=1u r_length=10u
X214 a_35349_76080# VTN.t31 VSS VSS nfet_03v3 ad=2.12p pd=8.53u as=3.56p ps=16.89u w=8u l=2u
X215 VSS NB.t62 a_39480_10659.t9 VSS nfet_03v3 ad=2.12p pd=8.53u as=2.12p ps=8.53u w=8u l=2u
X216 a_26920_15924# a_3849_72329.t13 cap_mim_2f0_m4m5_noshield c_width=52.2u c_length=52.2u
X217 a_1601_15740.t5 a_1400_1460.t64 VDD VDD pfet_03v3 ad=1.59p pd=6.53u as=1.59p ps=6.53u w=6u l=0.56u
X218 a_42705_5800# a_39227_6389# a_12117_10659.t0 VSS nfet_03v3 ad=0.89p pd=4.89u as=0.89p ps=4.89u w=2u l=0.28u
X219 VDD a_1400_1460.t85 a_1601_15740.t1 VDD pfet_03v3 ad=1.59p pd=6.53u as=1.59p ps=6.53u w=6u l=0.56u
X220 a_43680_10659.t0 a_44073_10449# OUTP.t12 VSS nfet_03v3 ad=1.325p pd=5.53u as=1.325p ps=5.53u w=5u l=0.28u
X221 a_1601_15740.t7 a_1601_15740.t6 VDD VDD pfet_03v3 ad=1.59p pd=6.53u as=2.67p ps=12.89u w=6u l=0.56u
X222 a_11681_10659.t13 a_39345_5800# VDD VDD pfet_03v3 ad=1.59p pd=6.53u as=2.67p ps=12.89u w=6u l=0.56u
X223 a_37373_76080# VTN.t5 VSS VSS nfet_03v3 ad=2.12p pd=8.53u as=2.12p ps=8.53u w=8u l=2u
X224 a_26880_10659.t10 NB.t149 VSS VSS nfet_03v3 ad=2.12p pd=8.53u as=2.12p ps=8.53u w=8u l=2u
X225 a_42705_5800# a_39227_6389# a_1400_1460.t1 VDD pfet_03v3 ad=1.78p pd=8.89u as=1.78p ps=8.89u w=4u l=0.28u
X226 a_23980_18046# a_24820_15924# VSS ppolyf_u_1k r_width=1u r_length=10u
X227 a_13620_18046# a_12780_15924# VSS ppolyf_u_1k r_width=1u r_length=10u
X228 VSS VTN.t10 a_36361_76080# VSS nfet_03v3 ad=2.12p pd=8.53u as=2.12p ps=8.53u w=8u l=2u
X229 VDD a_35349_62080.t7 a_35349_62080.t10 VDD pfet_03v3 ad=1.78p pd=8.89u as=1.06p ps=4.53u w=4u l=2u
X230 VDD a_1400_1460.t73 a_2037_15740.t1 VDD pfet_03v3 ad=1.59p pd=6.53u as=1.59p ps=6.53u w=6u l=0.56u
X231 a_3849_72329.t11 a_3849_72329.t1 VDD VDD pfet_03v3 ad=1.06p pd=4.53u as=1.06p ps=4.53u w=4u l=2u
X232 VSS VTN.t22 a_35349_76080# VSS nfet_03v3 ad=2.12p pd=8.53u as=2.12p ps=8.53u w=8u l=2u
X233 a_1469_11989.t3 G3A.t1 a_1400_1460.t17 VSS nfet_03v3 ad=0.89p pd=4.89u as=0.89p ps=4.89u w=2u l=0.28u
X234 a_37373_76080# VTN.t27 VSS VSS nfet_03v3 ad=2.12p pd=8.53u as=2.12p ps=8.53u w=8u l=2u
X235 VDD a_4409_66700.t2 a_4409_66700.t1 VDD pfet_03v3 ad=1.06p pd=4.53u as=1.06p ps=4.53u w=4u l=2u
X236 VSS NB.t128 a_43680_10659.t5 VSS nfet_03v3 ad=2.12p pd=8.53u as=2.12p ps=8.53u w=8u l=2u
X237 OUTN.t4 a_43749_11849# a_43680_10659.t0 VSS nfet_03v3 ad=1.325p pd=5.53u as=1.325p ps=5.53u w=5u l=0.28u
X238 VDD a_11549_11989.t5 a_11681_10659.t5 VDD pfet_03v3 ad=1.59p pd=6.53u as=1.59p ps=6.53u w=6u l=0.56u
X239 VDD a_2037_15740.t6 a_2037_15740.t7 VDD pfet_03v3 ad=1.59p pd=6.53u as=1.59p ps=6.53u w=6u l=0.56u
X240 VSS NB.t140 a_43680_10659.t3 VSS nfet_03v3 ad=2.12p pd=8.53u as=2.12p ps=8.53u w=8u l=2u
X241 a_10640_5800.t1 a_10785_5800.t11 VDD VDD pfet_03v3 ad=1.59p pd=6.53u as=2.67p ps=12.89u w=6u l=0.56u
X242 a_35349_66700.t6 a_34929_67569.t11 VDD VDD pfet_03v3 ad=1.06p pd=4.53u as=1.06p ps=4.53u w=4u l=2u
X243 a_35280_10659.t3 NB.t145 VSS VSS nfet_03v3 ad=2.12p pd=8.53u as=2.12p ps=8.53u w=8u l=2u
X244 VSS NB.t34 a_35280_10659.t14 VSS nfet_03v3 ad=2.12p pd=8.53u as=2.12p ps=8.53u w=8u l=2u
X245 VDD a_34789_72329.t11 a_34789_72329.t10 VDD pfet_03v3 ad=1.06p pd=4.53u as=1.06p ps=4.53u w=4u l=2u
X246 a_55480_18046# a_56320_15924# VSS ppolyf_u_1k r_width=1u r_length=10u
X247 VSS VTN.t46 a_3780_71559# VSS nfet_03v3 ad=2.12p pd=8.53u as=2.12p ps=8.53u w=8u l=2u
X248 a_34929_67569.t18 a_35349_66700.t1 cap_mim_2f0_m4m5_noshield c_width=20u c_length=20u
X249 a_3080_5800.t13 a_14145_5800.t4 VDD VDD pfet_03v3 ad=1.59p pd=6.53u as=1.59p ps=6.53u w=6u l=0.56u
X250 a_45120_18046# a_44280_15924# VSS ppolyf_u_1k r_width=1u r_length=10u
X251 VDD a_34789_72329.t27 a_35349_62080.t14 VDD pfet_03v3 ad=1.06p pd=4.53u as=1.06p ps=4.53u w=4u l=2u
X252 a_1601_15740.t13 a_39549_11849# a_39480_10659.t16 VSS nfet_03v3 ad=1.325p pd=5.53u as=2.225p ps=10.89u w=5u l=0.28u
X253 VDD a_3989_67569.t12 a_3989_67569.t11 VDD pfet_03v3 ad=1.78p pd=8.89u as=1.06p ps=4.53u w=4u l=2u
X254 a_31080_10659.t0 NB.t157 VSS VSS nfet_03v3 ad=2.12p pd=8.53u as=2.12p ps=8.53u w=8u l=2u
X255 VDD a_3849_72329.t1 a_4409_62080.t1 VDD pfet_03v3 ad=1.78p pd=8.89u as=1.06p ps=4.53u w=4u l=2u
X256 a_3225_1460# G3B.t0 a_1400_1460.t25 VSS nfet_03v3 ad=0.89p pd=4.89u as=0.89p ps=4.89u w=2u l=0.28u
X257 a_3780_71559# a_4409_62080.t1 a_4409_62080.t1 VSS nfet_03v3 ad=1.335p pd=6.89u as=0.795p ps=3.53u w=3u l=1u
X258 a_11681_10659.t6 a_11549_11989.t4 VDD VDD pfet_03v3 ad=1.59p pd=6.53u as=1.59p ps=6.53u w=6u l=0.56u
X259 VDD a_14145_5800.t4 a_3080_5800.t10 VDD pfet_03v3 ad=1.59p pd=6.53u as=1.59p ps=6.53u w=6u l=0.56u
X260 OUTP.t4 OUTP.t3 VDD VDD pfet_03v3 ad=1.59p pd=6.53u as=1.59p ps=6.53u w=6u l=0.56u
X261 VSS VTN.t60 a_5421_76080# VSS nfet_03v3 ad=2.12p pd=8.53u as=2.12p ps=8.53u w=8u l=2u
X262 OUTP.t10 a_44073_10449# a_43680_10659.t0 VSS nfet_03v3 ad=1.325p pd=5.53u as=1.325p ps=5.53u w=5u l=0.28u
X263 a_46800_18046# a_39873_10449# VSS ppolyf_u_1k r_width=1u r_length=10u
X264 a_36440_18046# a_35600_15924# VSS ppolyf_u_1k r_width=1u r_length=10u
X265 a_24400_18046# a_25240_15924# VSS ppolyf_u_1k r_width=1u r_length=10u
X266 a_14040_18046# a_13200_15924# VSS ppolyf_u_1k r_width=1u r_length=10u
X267 VDD a_35349_62080.t6 a_35349_62080.t5 VDD pfet_03v3 ad=1.78p pd=8.89u as=1.06p ps=4.53u w=4u l=2u
X268 VSS NB.t30 a_43680_10659.t14 VSS nfet_03v3 ad=2.12p pd=8.53u as=2.12p ps=8.53u w=8u l=2u
X269 VDD a_3989_67569.t13 a_4409_66700.t17 VDD pfet_03v3 ad=1.06p pd=4.53u as=1.06p ps=4.53u w=4u l=2u
X270 a_3849_72329.t19 a_4409_62080.t1 VDD VDD pfet_03v3 ad=1.06p pd=4.53u as=1.78p ps=8.89u w=4u l=2u
X271 OUTP.t13 a_1400_1460.t70 VDD VDD pfet_03v3 ad=1.59p pd=6.53u as=1.59p ps=6.53u w=6u l=0.56u
X272 a_3780_71559# VTN.t49 VSS VSS nfet_03v3 ad=2.12p pd=8.53u as=2.12p ps=8.53u w=8u l=2u
X273 a_4409_66700.t7 a_4409_66700.t6 VDD VDD pfet_03v3 ad=1.06p pd=4.53u as=1.78p ps=8.89u w=4u l=2u
X274 a_26880_10659.t24 NB.t1 VSS VSS nfet_03v3 ad=2.12p pd=8.53u as=2.12p ps=8.53u w=8u l=2u
X275 a_35349_76080# a_3080_5800.t18 a_35349_66700.t0 VSS nfet_03v3 ad=0.795p pd=3.53u as=0.795p ps=3.53u w=3u l=1u
X276 a_43680_10659.t0 a_44073_10449# OUTP.t9 VSS nfet_03v3 ad=1.325p pd=5.53u as=1.325p ps=5.53u w=5u l=0.28u
X277 a_15720_18046# a_16560_15924# VSS ppolyf_u_1k r_width=1u r_length=10u
X278 a_14145_5800.t3 G2B.t0 a_1400_1460.t20 VSS nfet_03v3 ad=0.89p pd=4.89u as=0.89p ps=4.89u w=2u l=0.28u
X279 a_11681_10659.t14 a_39345_5800# VDD VDD pfet_03v3 ad=1.59p pd=6.53u as=1.59p ps=6.53u w=6u l=0.56u
X280 VSS VTN.t56 a_3780_71559# VSS nfet_03v3 ad=2.12p pd=8.53u as=2.12p ps=8.53u w=8u l=2u
X281 a_3849_72329.t21 a_4409_62080.t2 cap_mim_2f0_m4m5_noshield c_width=16.58u c_length=16.58u
X282 a_34929_67569.t14 a_34929_67569.t11 VDD VDD pfet_03v3 ad=1.06p pd=4.53u as=1.06p ps=4.53u w=4u l=2u
X283 VDD a_1400_1460.t65 a_2037_15740.t5 VDD pfet_03v3 ad=1.59p pd=6.53u as=1.59p ps=6.53u w=6u l=0.56u
X284 VDD a_1400_1460.t67 OUTN.t7 VDD pfet_03v3 ad=1.59p pd=6.53u as=1.59p ps=6.53u w=6u l=0.56u
X285 a_35280_10659.t0 a_35349_11849# a_1601_10659.t16 VSS nfet_03v3 ad=1.325p pd=5.53u as=1.325p ps=5.53u w=5u l=0.28u
X286 a_43680_10659.t13 NB.t49 VSS VSS nfet_03v3 ad=2.12p pd=8.53u as=2.12p ps=8.53u w=8u l=2u
X287 a_2037_15740.t1 a_1400_1460.t74 VDD VDD pfet_03v3 ad=1.59p pd=6.53u as=1.59p ps=6.53u w=6u l=0.56u
X288 a_36361_76080# VTN.t21 VSS VSS nfet_03v3 ad=2.12p pd=8.53u as=2.12p ps=8.53u w=8u l=2u
X289 a_11985_10449.t2 G1B.t2 a_12117_10659.t11 VDD pfet_03v3 ad=1.78p pd=8.89u as=1.78p ps=8.89u w=4u l=0.28u
X290 VSS NB.t4 a_35280_10659.t17 VSS nfet_03v3 ad=2.12p pd=8.53u as=2.12p ps=8.53u w=8u l=2u
X291 a_1545_1460# G3B.t1 a_1400_1460.t26 VSS nfet_03v3 ad=0.89p pd=4.89u as=0.89p ps=4.89u w=2u l=0.28u
X292 OUTN.t1 a_43749_11849# a_43680_10659.t0 VSS nfet_03v3 ad=1.325p pd=5.53u as=1.325p ps=5.53u w=5u l=0.28u
X293 a_8580_18046# a_9420_15924# VSS ppolyf_u_1k r_width=1u r_length=10u
X294 a_3989_67569.t18 a_4409_62080.t26 a_5421_76080# VSS nfet_03v3 ad=0.795p pd=3.53u as=0.795p ps=3.53u w=3u l=1u
X295 VSS NB.t16 a_39480_10659.t14 VSS nfet_03v3 ad=2.12p pd=8.53u as=2.12p ps=8.53u w=8u l=2u
X296 a_3989_67569.t1 a_4409_66700.t21 VDD VDD pfet_03v3 ad=1.06p pd=4.53u as=1.06p ps=4.53u w=4u l=2u
X297 a_3849_72329.t17 a_4409_62080.t24 VDD VDD pfet_03v3 ad=1.06p pd=4.53u as=1.78p ps=8.89u w=4u l=2u
X298 a_43680_10659.t15 NB.t21 VSS VSS nfet_03v3 ad=2.12p pd=8.53u as=2.12p ps=8.53u w=8u l=2u
X299 a_11681_10659.t5 a_11549_11989.t6 VDD VDD pfet_03v3 ad=1.59p pd=6.53u as=1.59p ps=6.53u w=6u l=0.56u
X300 a_26500_15924# a_4409_62080.t6 cap_mim_2f0_m4m5_noshield c_width=52.2u c_length=52.2u
X301 a_2037_10659.t16 a_35673_10449# a_35280_10659.t0 VSS nfet_03v3 ad=1.325p pd=5.53u as=1.325p ps=5.53u w=5u l=0.28u
X302 a_5421_76080# VTN.t35 VSS VSS nfet_03v3 ad=2.12p pd=8.53u as=2.12p ps=8.53u w=8u l=2u
X303 VSS NB.t40 a_26880_10659.t20 VSS nfet_03v3 ad=3.56p pd=16.89u as=2.12p ps=8.53u w=8u l=2u
X304 a_26880_10659.t15 NB.t91 VSS VSS nfet_03v3 ad=2.12p pd=8.53u as=2.12p ps=8.53u w=8u l=2u
X305 a_35280_10659.t13 NB.t45 VSS VSS nfet_03v3 ad=2.12p pd=8.53u as=2.12p ps=8.53u w=8u l=2u
X306 VDD a_10785_5800.t6 a_10640_5800.t3 VDD pfet_03v3 ad=1.59p pd=6.53u as=1.59p ps=6.53u w=6u l=0.56u
X307 VDD a_14145_5800.t4 a_3080_5800.t12 VDD pfet_03v3 ad=1.59p pd=6.53u as=1.59p ps=6.53u w=6u l=0.56u
X308 a_34720_71559# VTN.t17 VSS VSS nfet_03v3 ad=2.12p pd=8.53u as=2.12p ps=8.53u w=8u l=2u
X309 a_34929_67569.t9 a_34929_67569.t8 VDD VDD pfet_03v3 ad=1.06p pd=4.53u as=1.06p ps=4.53u w=4u l=2u
X310 a_35349_66700.t14 a_35349_66700.t13 VDD VDD pfet_03v3 ad=1.06p pd=4.53u as=1.78p ps=8.89u w=4u l=2u
X311 a_4409_76080# a_11681_10659.t18 a_3989_67569.t4 VSS nfet_03v3 ad=1.335p pd=6.89u as=0.795p ps=3.53u w=3u l=1u
X312 VDD a_34789_72329.t17 a_34789_72329.t16 VDD pfet_03v3 ad=1.06p pd=4.53u as=1.06p ps=4.53u w=4u l=2u
X313 a_43680_10659.t0 a_43749_11849# OUTN.t3 VSS nfet_03v3 ad=1.325p pd=5.53u as=1.325p ps=5.53u w=5u l=0.28u
X314 a_4409_62080.t1 a_4409_62080.t1 a_3780_71559# VSS nfet_03v3 ad=0.795p pd=3.53u as=0.795p ps=3.53u w=3u l=1u
X315 a_39480_10659.t10 NB.t57 VSS VSS nfet_03v3 ad=2.12p pd=8.53u as=2.12p ps=8.53u w=8u l=2u
X316 VDD a_11985_10449.t3 a_12117_10659.t17 VDD pfet_03v3 ad=1.59p pd=6.53u as=1.59p ps=6.53u w=6u l=0.56u
X317 VSS NB.t64 a_35280_10659.t11 VSS nfet_03v3 ad=2.12p pd=8.53u as=2.12p ps=8.53u w=8u l=2u
X318 a_36361_76080# a_34789_72329.t33 a_35349_66700.t19 VSS nfet_03v3 ad=0.795p pd=3.53u as=0.795p ps=3.53u w=3u l=1u
X319 VSS NB.t82 a_31080_10659.t7 VSS nfet_03v3 ad=2.12p pd=8.53u as=2.12p ps=8.53u w=8u l=2u
X320 VSS NB.t76 a_31080_10659.t8 VSS nfet_03v3 ad=2.12p pd=8.53u as=2.12p ps=8.53u w=8u l=2u
X321 VSS NB.t152 a_39480_10659.t0 VSS nfet_03v3 ad=2.12p pd=8.53u as=2.12p ps=8.53u w=8u l=2u
X322 a_35280_10659.t1 a_35673_10449# a_2037_10659.t15 VSS nfet_03v3 ad=1.325p pd=5.53u as=1.325p ps=5.53u w=5u l=0.28u
X323 a_35349_62080.t0 a_35349_66700.t30 a_37373_76080# VSS nfet_03v3 ad=0.795p pd=3.53u as=0.795p ps=3.53u w=3u l=1u
X324 a_39480_10659.t7 NB.t87 VSS VSS nfet_03v3 ad=2.12p pd=8.53u as=2.12p ps=8.53u w=8u l=2u
X325 VDD a_1400_1460.t71 a_1601_15740.t0 VDD pfet_03v3 ad=1.59p pd=6.53u as=1.59p ps=6.53u w=6u l=0.56u
X326 VDD a_34929_67569.t19 a_35349_66700.t4 VDD pfet_03v3 ad=1.78p pd=8.89u as=1.06p ps=4.53u w=4u l=2u
X327 a_35349_62080.t20 a_34789_72329.t1 cap_mim_2f0_m4m5_noshield c_width=25.98u c_length=25.98u
X328 a_43680_10659.t0 a_43749_11849# OUTN.t2 VSS nfet_03v3 ad=1.325p pd=5.53u as=1.325p ps=5.53u w=5u l=0.28u
X329 a_53800_18046# a_52960_15924# VSS ppolyf_u_1k r_width=1u r_length=10u
X330 a_41760_18046# a_42600_15924# VSS ppolyf_u_1k r_width=1u r_length=10u
X331 a_3849_72329.t9 a_3849_72329.t1 VDD VDD pfet_03v3 ad=1.06p pd=4.53u as=1.78p ps=8.89u w=4u l=2u
X332 a_31080_10659.t3 NB.t123 VSS VSS nfet_03v3 ad=2.12p pd=8.53u as=2.12p ps=8.53u w=8u l=2u
X333 a_31400_18046# a_30560_15924# VSS ppolyf_u_1k r_width=1u r_length=10u
X334 a_19360_18046# a_20200_15924# VSS ppolyf_u_1k r_width=1u r_length=10u
X335 VSS NB.t106 a_31080_10659.t5 VSS nfet_03v3 ad=2.12p pd=8.53u as=2.12p ps=8.53u w=8u l=2u
X336 VDD a_42705_5800# a_12117_10659.t13 VDD pfet_03v3 ad=1.59p pd=6.53u as=1.59p ps=6.53u w=6u l=0.56u
X337 VDD a_42705_5800# a_12117_10659.t12 VDD pfet_03v3 ad=1.59p pd=6.53u as=1.59p ps=6.53u w=6u l=0.56u
X338 VDD a_2037_15740.t6 a_2037_15740.t9 VDD pfet_03v3 ad=1.59p pd=6.53u as=1.59p ps=6.53u w=6u l=0.56u
X339 a_18940_18046# a_1400_1460.t5 VSS ppolyf_u_1k r_width=1u r_length=10u
X340 OUTN.t7 a_1400_1460.t68 VDD VDD pfet_03v3 ad=1.59p pd=6.53u as=1.59p ps=6.53u w=6u l=0.56u
X341 a_35349_66700.t5 a_34929_67569.t11 VDD VDD pfet_03v3 ad=1.06p pd=4.53u as=1.78p ps=8.89u w=4u l=2u
X342 a_44073_10449# a_1601_15740.t3 cap_mim_2f0_m4m5_noshield c_width=52.2u c_length=52.2u
X343 a_36361_76080# VTN.t3 VSS VSS nfet_03v3 ad=2.12p pd=8.53u as=2.12p ps=8.53u w=8u l=2u
X344 a_33080_18046# a_33920_15924# VSS ppolyf_u_1k r_width=1u r_length=10u
X345 a_22720_18046# a_21880_15924# VSS ppolyf_u_1k r_width=1u r_length=10u
X346 VSS VTN.t8 a_35349_76080# VSS nfet_03v3 ad=2.12p pd=8.53u as=2.12p ps=8.53u w=8u l=2u
X347 a_10680_18046# a_11520_15924# VSS ppolyf_u_1k r_width=1u r_length=10u
X348 a_42705_5800# G1A.t0 a_1400_1460.t16 VSS nfet_03v3 ad=0.89p pd=4.89u as=0.89p ps=4.89u w=2u l=0.28u
X349 a_31080_10659.t14 NB.t13 VSS VSS nfet_03v3 ad=2.12p pd=8.53u as=2.12p ps=8.53u w=8u l=2u
X350 VSS NB.t102 a_39480_10659.t5 VSS nfet_03v3 ad=2.12p pd=8.53u as=2.12p ps=8.53u w=8u l=2u
X351 OUTP.t12 a_44073_10449# a_43680_10659.t0 VSS nfet_03v3 ad=1.325p pd=5.53u as=1.325p ps=5.53u w=5u l=0.28u
X352 VDD a_10785_5800.t8 a_10640_5800.t2 VDD pfet_03v3 ad=1.59p pd=6.53u as=1.59p ps=6.53u w=6u l=0.56u
X353 a_3080_5800.t5 a_3080_5800.t4 VDD VDD pfet_03v3 ad=1.59p pd=6.53u as=1.59p ps=6.53u w=6u l=0.56u
X354 a_34720_71559# VTN.t25 VSS VSS nfet_03v3 ad=2.12p pd=8.53u as=2.12p ps=8.53u w=8u l=2u
X355 VSS NB.t126 a_39480_10659.t3 VSS nfet_03v3 ad=2.12p pd=8.53u as=2.12p ps=8.53u w=8u l=2u
X356 a_4409_62080.t20 a_3849_72329.t15 cap_mim_2f0_m4m5_noshield c_width=16.58u c_length=16.58u
X357 VSS NB.t138 a_43680_10659.t4 VSS nfet_03v3 ad=2.12p pd=8.53u as=2.12p ps=8.53u w=8u l=2u
X358 a_1905_10449# a_17789_5800.t2 a_2037_10659.t6 VSS nfet_03v3 ad=0.89p pd=4.89u as=0.89p ps=4.89u w=2u l=0.28u
X359 a_2037_10659.t16 a_35673_10449# a_35280_10659.t0 VSS nfet_03v3 ad=1.325p pd=5.53u as=1.325p ps=5.53u w=5u l=0.28u
X360 a_39480_10659.t1 NB.t143 VSS VSS nfet_03v3 ad=2.12p pd=8.53u as=2.12p ps=8.53u w=8u l=2u
X361 a_39345_5800# a_39227_6389# a_11681_10659.t0 VSS nfet_03v3 ad=0.89p pd=4.89u as=0.89p ps=4.89u w=2u l=0.28u
X362 VDD a_34789_72329.t14 a_34789_72329.t13 VDD pfet_03v3 ad=1.78p pd=8.89u as=1.06p ps=4.53u w=4u l=2u
X363 a_1469_11989.t2 G3A.t3 a_1601_10659.t9 VDD pfet_03v3 ad=1.78p pd=8.89u as=1.78p ps=8.89u w=4u l=0.28u
X364 a_35280_10659.t0 a_35349_11849# a_1601_10659.t15 VSS nfet_03v3 ad=2.225p pd=10.89u as=1.325p ps=5.53u w=5u l=0.28u
X365 a_53380_18046# a_54220_15924# VSS ppolyf_u_1k r_width=1u r_length=10u
X366 a_43020_18046# a_42180_15924# VSS ppolyf_u_1k r_width=1u r_length=10u
X367 VSS VTN.t44 a_6433_76080# VSS nfet_03v3 ad=2.12p pd=8.53u as=2.12p ps=8.53u w=8u l=2u
X368 a_3989_67569.t16 a_3989_67569.t13 VDD VDD pfet_03v3 ad=1.06p pd=4.53u as=1.06p ps=4.53u w=4u l=2u
X369 VDD a_34789_72329.t25 a_35349_62080.t15 VDD pfet_03v3 ad=1.78p pd=8.89u as=1.06p ps=4.53u w=4u l=2u
X370 a_43680_10659.t0 a_44073_10449# OUTP.t11 VSS nfet_03v3 ad=1.325p pd=5.53u as=1.325p ps=5.53u w=5u l=0.28u
X371 VDD a_4409_62080.t1 a_4409_62080.t16 VDD pfet_03v3 ad=1.06p pd=4.53u as=1.06p ps=4.53u w=4u l=2u
X372 a_35280_10659.t2 NB.t155 VSS VSS nfet_03v3 ad=2.12p pd=8.53u as=2.12p ps=8.53u w=8u l=2u
X373 a_3989_67569.t8 a_3989_67569.t7 VDD VDD pfet_03v3 ad=1.06p pd=4.53u as=1.78p ps=8.89u w=4u l=2u
X374 a_14145_5800.t2 G2B.t2 a_3080_5800.t8 VDD pfet_03v3 ad=1.78p pd=8.89u as=1.78p ps=8.89u w=4u l=0.28u
X375 a_19360_18046# a_1400_1460.t31 VSS ppolyf_u_1k r_width=1u r_length=10u
X376 OUTN.t0 a_1400_1460.t58 VDD VDD pfet_03v3 ad=1.59p pd=6.53u as=1.59p ps=6.53u w=6u l=0.56u
X377 a_56740_18046# a_55900_15924# VSS ppolyf_u_1k r_width=1u r_length=10u
X378 VSS VTN.t58 a_6433_76080# VSS nfet_03v3 ad=2.12p pd=8.53u as=2.12p ps=8.53u w=8u l=2u
X379 a_39480_10659.t8 NB.t73 VSS VSS nfet_03v3 ad=2.12p pd=8.53u as=2.12p ps=8.53u w=8u l=2u
X380 a_44700_18046# a_45540_15924# VSS ppolyf_u_1k r_width=1u r_length=10u
X381 a_34340_18046# a_33500_15924# VSS ppolyf_u_1k r_width=1u r_length=10u
X382 VSS NB.t28 a_26880_10659.t22 VSS nfet_03v3 ad=2.12p pd=8.53u as=2.12p ps=8.53u w=8u l=2u
X383 a_22300_18046# a_23140_15924# VSS ppolyf_u_1k r_width=1u r_length=10u
X384 VDD a_35349_62080.t23 a_34789_72329.t3 VDD pfet_03v3 ad=1.06p pd=4.53u as=1.06p ps=4.53u w=4u l=2u
X385 VDD a_4409_66700.t24 a_3989_67569.t2 VDD pfet_03v3 ad=1.78p pd=8.89u as=1.06p ps=4.53u w=4u l=2u
X386 VDD a_3989_67569.t13 a_4409_66700.t18 VDD pfet_03v3 ad=1.78p pd=8.89u as=1.06p ps=4.53u w=4u l=2u
X387 OUTN.t2 a_43749_11849# a_43680_10659.t0 VSS nfet_03v3 ad=1.325p pd=5.53u as=2.225p ps=10.89u w=5u l=0.28u
X388 VSS NB.t52 a_31080_10659.t10 VSS nfet_03v3 ad=2.12p pd=8.53u as=2.12p ps=8.53u w=8u l=2u
X389 a_1905_10449# G3A.t0 a_1400_1460.t18 VSS nfet_03v3 ad=0.89p pd=4.89u as=0.89p ps=4.89u w=2u l=0.28u
X390 a_36020_18046# a_35349_11849# VSS ppolyf_u_1k r_width=1u r_length=10u
X391 VSS NB.t158 a_26880_10659.t9 VSS nfet_03v3 ad=2.12p pd=8.53u as=2.12p ps=8.53u w=8u l=2u
X392 a_25660_18046# a_24820_15924# VSS ppolyf_u_1k r_width=1u r_length=10u
X393 a_13620_18046# a_14460_15924# VSS ppolyf_u_1k r_width=1u r_length=10u
X394 VSS VTN.t54 a_4409_76080# VSS nfet_03v3 ad=2.12p pd=8.53u as=2.12p ps=8.53u w=8u l=2u
X395 a_2037_10659.t16 a_35673_10449# a_35280_10659.t0 VSS nfet_03v3 ad=1.325p pd=5.53u as=1.325p ps=5.53u w=5u l=0.28u
X396 VSS VTN.t0 a_35349_76080# VSS nfet_03v3 ad=3.56p pd=16.89u as=2.12p ps=8.53u w=8u l=2u
X397 a_3989_67569.t3 a_4409_66700.t23 VDD VDD pfet_03v3 ad=1.06p pd=4.53u as=1.78p ps=8.89u w=4u l=2u
X398 VDD a_4409_62080.t12 a_4409_62080.t11 VDD pfet_03v3 ad=1.06p pd=4.53u as=1.06p ps=4.53u w=4u l=2u
X399 a_6869_5800.t0 G2B.t5 VSS VSS nfet_03v3 ad=1.78p pd=8.89u as=1.78p ps=8.89u w=4u l=1u
X400 a_1469_11989.t0 a_17789_5800.t3 a_1601_10659.t8 VSS nfet_03v3 ad=0.89p pd=4.89u as=0.89p ps=4.89u w=2u l=0.28u
X401 a_12117_10659.t9 a_16560_15924# a_26880_10659.t0 VSS nfet_03v3 ad=1.325p pd=5.53u as=1.325p ps=5.53u w=5u l=0.28u
X402 a_57160_18046# a_56320_15924# VSS ppolyf_u_1k r_width=1u r_length=10u
X403 a_35349_66700.t11 a_35349_66700.t10 VDD VDD pfet_03v3 ad=1.06p pd=4.53u as=1.06p ps=4.53u w=4u l=2u
X404 a_34929_67569.t6 a_34929_67569.t5 VDD VDD pfet_03v3 ad=1.06p pd=4.53u as=1.78p ps=8.89u w=4u l=2u
X405 a_35280_10659.t0 a_35349_11849# a_1601_10659.t16 VSS nfet_03v3 ad=1.325p pd=5.53u as=1.325p ps=5.53u w=5u l=0.28u
X406 VDD a_11549_11989.t3 a_11681_10659.t6 VDD pfet_03v3 ad=2.67p pd=12.89u as=1.59p ps=6.53u w=6u l=0.56u
X407 a_43680_10659.t12 NB.t59 VSS VSS nfet_03v3 ad=2.12p pd=8.53u as=2.12p ps=8.53u w=8u l=2u
X408 a_3989_67569.t19 a_4409_66700.t13 cap_mim_2f0_m4m5_noshield c_width=30.82u c_length=30.82u
X409 VDD OUTP.t5 OUTP.t4 VDD pfet_03v3 ad=1.59p pd=6.53u as=1.59p ps=6.53u w=6u l=0.56u
X410 VDD a_3080_5800.t3 a_3080_5800.t2 VDD pfet_03v3 ad=1.59p pd=6.53u as=1.59p ps=6.53u w=6u l=0.56u
X411 VDD OUTP.t2 OUTP.t1 VDD pfet_03v3 ad=1.59p pd=6.53u as=1.59p ps=6.53u w=6u l=0.56u
X412 a_1601_15740.t2 a_1400_1460.t62 VDD VDD pfet_03v3 ad=1.59p pd=6.53u as=2.67p ps=12.89u w=6u l=0.56u
X413 a_3225_1460# a_3107_2049.t2 a_2037_10659.t19 VSS nfet_03v3 ad=0.89p pd=4.89u as=0.89p ps=4.89u w=2u l=0.28u
X414 a_10640_5800.t4 a_10785_5800.t5 VDD VDD pfet_03v3 ad=1.59p pd=6.53u as=1.59p ps=6.53u w=6u l=0.56u
X415 a_4409_76080# VTN.t33 VSS VSS nfet_03v3 ad=2.12p pd=8.53u as=2.12p ps=8.53u w=8u l=2u
X416 a_6433_76080# a_4409_66700.t28 a_4409_62080.t0 VSS nfet_03v3 ad=1.335p pd=6.89u as=0.795p ps=3.53u w=3u l=1u
X417 a_39480_10659.t21 a_39549_11849# a_1601_15740.t12 VSS nfet_03v3 ad=1.325p pd=5.53u as=1.325p ps=5.53u w=5u l=0.28u
X418 a_36440_18046# a_35673_10449# VSS ppolyf_u_1k r_width=1u r_length=10u
X419 a_26080_18046# a_25240_15924# VSS ppolyf_u_1k r_width=1u r_length=10u
X420 VSS NB.t154 a_35280_10659.t2 VSS nfet_03v3 ad=2.12p pd=8.53u as=2.12p ps=8.53u w=8u l=2u
X421 a_43680_10659.t9 NB.t89 VSS VSS nfet_03v3 ad=2.12p pd=8.53u as=2.12p ps=8.53u w=8u l=2u
X422 a_9000_18046# a_9840_15924# VSS ppolyf_u_1k r_width=1u r_length=10u
X423 a_43680_10659.t0 a_44073_10449# OUTP.t10 VSS nfet_03v3 ad=1.325p pd=5.53u as=1.325p ps=5.53u w=5u l=0.28u
X424 a_43749_11849# a_2037_15740.t2 cap_mim_2f0_m4m5_noshield c_width=52.2u c_length=52.2u
X425 a_26880_10659.t6 a_16560_15924# a_12117_10659.t10 VSS nfet_03v3 ad=1.325p pd=5.53u as=1.325p ps=5.53u w=5u l=0.28u
X426 a_34720_71559# VTN.t15 VSS VSS nfet_03v3 ad=2.12p pd=8.53u as=2.12p ps=8.53u w=8u l=2u
X427 a_34720_71559# a_34789_72329.t23 a_34789_72329.t22 VSS nfet_03v3 ad=0.795p pd=3.53u as=0.795p ps=3.53u w=3u l=1u
X428 a_35280_10659.t12 NB.t55 VSS VSS nfet_03v3 ad=2.12p pd=8.53u as=2.12p ps=8.53u w=8u l=2u
X429 a_35280_10659.t0 a_35349_11849# a_1601_10659.t16 VSS nfet_03v3 ad=1.325p pd=5.53u as=1.325p ps=5.53u w=5u l=0.28u
X430 VDD a_1400_1460.t59 a_2037_15740.t0 VDD pfet_03v3 ad=1.59p pd=6.53u as=1.59p ps=6.53u w=6u l=0.56u
X431 a_1601_10659.t16 a_35349_11849# a_35280_10659.t0 VSS nfet_03v3 ad=1.325p pd=5.53u as=1.325p ps=5.53u w=5u l=0.28u
X432 OUTN.t3 a_43749_11849# a_43680_10659.t0 VSS nfet_03v3 ad=1.325p pd=5.53u as=1.325p ps=5.53u w=5u l=0.28u
X433 a_1545_1460# a_3107_2049.t3 a_1601_10659.t17 VSS nfet_03v3 ad=0.89p pd=4.89u as=0.89p ps=4.89u w=2u l=0.28u
X434 a_2037_15740.t5 a_1400_1460.t66 VDD VDD pfet_03v3 ad=1.59p pd=6.53u as=1.59p ps=6.53u w=6u l=0.56u
X435 VSS NB.t80 a_26880_10659.t16 VSS nfet_03v3 ad=3.56p pd=16.89u as=2.12p ps=8.53u w=8u l=2u
X436 a_11549_11989.t0 a_45947_6389# a_1400_1460.t7 VDD pfet_03v3 ad=1.78p pd=8.89u as=1.78p ps=8.89u w=4u l=0.28u
X437 VDD a_34929_67569.t11 a_34929_67569.t12 VDD pfet_03v3 ad=1.06p pd=4.53u as=1.06p ps=4.53u w=4u l=2u
X438 VSS NB.t150 a_43680_10659.t2 VSS nfet_03v3 ad=2.12p pd=8.53u as=2.12p ps=8.53u w=8u l=2u
X439 a_35280_10659.t9 NB.t85 VSS VSS nfet_03v3 ad=2.12p pd=8.53u as=2.12p ps=8.53u w=8u l=2u
X440 a_26880_10659.t17 NB.t79 VSS VSS nfet_03v3 ad=2.12p pd=8.53u as=3.56p ps=16.89u w=8u l=2u
X441 a_34929_67569.t3 a_35349_66700.t26 VDD VDD pfet_03v3 ad=1.06p pd=4.53u as=1.06p ps=4.53u w=4u l=2u
X442 VDD a_35349_62080.t7 a_34789_72329.t5 VDD pfet_03v3 ad=1.06p pd=4.53u as=1.06p ps=4.53u w=4u l=2u
X443 a_39480_10659.t6 NB.t97 VSS VSS nfet_03v3 ad=2.12p pd=8.53u as=2.12p ps=8.53u w=8u l=2u
X444 a_17789_5800.t1 G3A.t4 VDD VDD pfet_03v3 ad=1.78p pd=8.89u as=1.78p ps=8.89u w=4u l=1u
X445 a_51700_18046# a_50860_15924# VSS ppolyf_u_1k r_width=1u r_length=10u
X446 a_26880_10659.t12 NB.t121 VSS VSS nfet_03v3 ad=2.12p pd=8.53u as=2.12p ps=8.53u w=8u l=2u
X447 a_39660_18046# a_40500_15924# VSS ppolyf_u_1k r_width=1u r_length=10u
X448 VSS NB.t104 a_35280_10659.t7 VSS nfet_03v3 ad=2.12p pd=8.53u as=2.12p ps=8.53u w=8u l=2u
X449 a_2037_10659.t15 a_35673_10449# a_35280_10659.t0 VSS nfet_03v3 ad=1.325p pd=5.53u as=1.325p ps=5.53u w=5u l=0.28u
X450 a_11681_10659.t8 a_11681_10659.t7 VDD VDD pfet_03v3 ad=1.59p pd=6.53u as=2.67p ps=12.89u w=6u l=0.56u
X451 VDD a_1400_1460.t63 a_1601_15740.t5 VDD pfet_03v3 ad=2.67p pd=12.89u as=1.59p ps=6.53u w=6u l=0.56u
X452 a_1400_1460.t32 NB.t161 VSS VSS nfet_03v3 ad=2.12p pd=8.53u as=3.56p ps=16.89u w=8u l=2u
X453 VSS NB.t116 a_31080_10659.t4 VSS nfet_03v3 ad=2.12p pd=8.53u as=2.12p ps=8.53u w=8u l=2u
X454 a_39480_10659.t22 a_39873_10449# a_2037_15740.t14 VSS nfet_03v3 ad=1.325p pd=5.53u as=1.325p ps=5.53u w=5u l=0.28u
X455 a_35349_66700.t20 a_34929_67569.t16 cap_mim_2f0_m4m5_noshield c_width=20u c_length=20u
X456 a_4409_66700.t9 a_4409_66700.t6 VDD VDD pfet_03v3 ad=1.06p pd=4.53u as=1.06p ps=4.53u w=4u l=2u
X457 a_26880_10659.t7 a_16140_15924# a_11681_10659.t16 VSS nfet_03v3 ad=2.225p pd=10.89u as=1.325p ps=5.53u w=5u l=0.28u
X458 a_30980_18046# a_31820_15924# VSS ppolyf_u_1k r_width=1u r_length=10u
X459 a_20620_18046# a_19780_15924# VSS ppolyf_u_1k r_width=1u r_length=10u
X460 VSS VTN.t6 a_34720_71559# VSS nfet_03v3 ad=2.12p pd=8.53u as=2.12p ps=8.53u w=8u l=2u
X461 a_3989_67569.t14 a_3989_67569.t13 VDD VDD pfet_03v3 ad=1.06p pd=4.53u as=1.78p ps=8.89u w=4u l=2u
X462 a_10640_5800.t3 a_10785_5800.t7 VDD VDD pfet_03v3 ad=1.59p pd=6.53u as=1.59p ps=6.53u w=6u l=0.56u
X463 a_3989_67569.t4 a_11681_10659.t19 a_4409_76080# VSS nfet_03v3 ad=0.795p pd=3.53u as=0.795p ps=3.53u w=3u l=1u
X464 VDD a_1400_1460.t35 a_1400_1460.t34 VDD pfet_03v3 ad=2.67p pd=12.89u as=1.59p ps=6.53u w=6u l=0.56u
X465 a_4409_62080.t1 a_3849_72329.t1 VDD VDD pfet_03v3 ad=1.06p pd=4.53u as=1.06p ps=4.53u w=4u l=2u
X466 a_26880_10659.t23 NB.t11 VSS VSS nfet_03v3 ad=2.12p pd=8.53u as=2.12p ps=8.53u w=8u l=2u
X467 a_35280_10659.t0 a_35673_10449# a_2037_10659.t16 VSS nfet_03v3 ad=1.325p pd=5.53u as=1.325p ps=5.53u w=5u l=0.28u
X468 OUTP.t14 a_1400_1460.t56 VDD VDD pfet_03v3 ad=1.59p pd=6.53u as=1.59p ps=6.53u w=6u l=0.56u
X469 a_35349_76080# VTN.t23 VSS VSS nfet_03v3 ad=2.12p pd=8.53u as=2.12p ps=8.53u w=8u l=2u
X470 VSS NB.t124 a_35280_10659.t5 VSS nfet_03v3 ad=2.12p pd=8.53u as=2.12p ps=8.53u w=8u l=2u
X471 a_11549_11989.t1 a_45947_6389# a_11681_10659.t1 VSS nfet_03v3 ad=0.89p pd=4.89u as=0.89p ps=4.89u w=2u l=0.28u
X472 a_1601_15740.t12 a_39549_11849# a_39480_10659.t20 VSS nfet_03v3 ad=1.325p pd=5.53u as=1.325p ps=5.53u w=5u l=0.28u
X473 a_5421_76080# VTN.t61 VSS VSS nfet_03v3 ad=2.12p pd=8.53u as=2.12p ps=8.53u w=8u l=2u
X474 OUTP.t1 OUTP.t0 VDD VDD pfet_03v3 ad=1.59p pd=6.53u as=1.59p ps=6.53u w=6u l=0.56u
X475 a_42705_5800# G1A.t2 a_12117_10659.t8 VDD pfet_03v3 ad=1.78p pd=8.89u as=1.78p ps=8.89u w=4u l=0.28u
X476 a_11940_18046# a_11100_15924# VSS ppolyf_u_1k r_width=1u r_length=10u
X477 VSS NB.t136 a_39480_10659.t2 VSS nfet_03v3 ad=2.12p pd=8.53u as=2.12p ps=8.53u w=8u l=2u
X478 a_43680_10659.t3 NB.t141 VSS VSS nfet_03v3 ad=2.12p pd=8.53u as=2.12p ps=8.53u w=8u l=2u
X479 a_52120_18046# a_51280_15924# VSS ppolyf_u_1k r_width=1u r_length=10u
X480 VSS VTN.t42 a_5421_76080# VSS nfet_03v3 ad=2.12p pd=8.53u as=2.12p ps=8.53u w=8u l=2u
X481 VDD a_4409_62080.t1 a_4409_62080.t18 VDD pfet_03v3 ad=1.78p pd=8.89u as=1.06p ps=4.53u w=4u l=2u
X482 a_1601_10659.t16 a_35349_11849# a_35280_10659.t0 VSS nfet_03v3 ad=1.325p pd=5.53u as=2.225p ps=10.89u w=5u l=0.28u
X483 VSS NB.t2 a_31080_10659.t15 VSS nfet_03v3 ad=2.12p pd=8.53u as=2.12p ps=8.53u w=8u l=2u
X484 a_26880_10659.t5 a_16140_15924# a_11681_10659.t15 VSS nfet_03v3 ad=1.325p pd=5.53u as=1.325p ps=5.53u w=5u l=0.28u
X485 VSS NB.t54 a_35280_10659.t12 VSS nfet_03v3 ad=2.12p pd=8.53u as=2.12p ps=8.53u w=8u l=2u
X486 a_12117_10659.t6 a_12117_10659.t5 VDD VDD pfet_03v3 ad=1.59p pd=6.53u as=1.59p ps=6.53u w=6u l=0.56u
X487 VDD a_1400_1460.t53 a_1601_15740.t2 VDD pfet_03v3 ad=1.59p pd=6.53u as=1.59p ps=6.53u w=6u l=0.56u
X488 a_39480_10659.t15 NB.t7 VSS VSS nfet_03v3 ad=2.12p pd=8.53u as=2.12p ps=8.53u w=8u l=2u
X489 a_39660_18046# a_1400_1460.t13 VSS ppolyf_u_1k r_width=1u r_length=10u
X490 a_1469_11989.t1 a_17789_5800.t5 a_1400_1460.t9 VDD pfet_03v3 ad=1.78p pd=8.89u as=1.78p ps=8.89u w=4u l=0.28u
X491 a_1601_10659.t15 a_35349_11849# a_35280_10659.t1 VSS nfet_03v3 ad=1.325p pd=5.53u as=1.325p ps=5.53u w=5u l=0.28u
X492 a_2037_15740.t11 a_39873_10449# a_39480_10659.t19 VSS nfet_03v3 ad=1.325p pd=5.53u as=1.325p ps=5.53u w=5u l=0.28u
X493 a_53800_18046# a_54640_15924# VSS ppolyf_u_1k r_width=1u r_length=10u
X494 a_43440_18046# a_42600_15924# VSS ppolyf_u_1k r_width=1u r_length=10u
X495 a_43680_10659.t10 NB.t71 VSS VSS nfet_03v3 ad=2.12p pd=8.53u as=2.12p ps=8.53u w=8u l=2u
X496 a_31400_18046# a_32240_15924# VSS ppolyf_u_1k r_width=1u r_length=10u
X497 a_21040_18046# a_20200_15924# VSS ppolyf_u_1k r_width=1u r_length=10u
X498 VDD a_35349_62080.t21 a_34789_72329.t4 VDD pfet_03v3 ad=1.78p pd=8.89u as=1.06p ps=4.53u w=4u l=2u
X499 VSS NB.t26 a_31080_10659.t13 VSS nfet_03v3 ad=2.12p pd=8.53u as=2.12p ps=8.53u w=8u l=2u
X500 a_12117_10659.t9 a_16560_15924# a_26880_10659.t3 VSS nfet_03v3 ad=1.325p pd=5.53u as=1.325p ps=5.53u w=5u l=0.28u
X501 VDD a_3849_72329.t5 a_3849_72329.t4 VDD pfet_03v3 ad=1.06p pd=4.53u as=1.06p ps=4.53u w=4u l=2u
X502 a_39480_10659.t23 a_39549_11849# a_1601_15740.t14 VSS nfet_03v3 ad=2.225p pd=10.89u as=1.325p ps=5.53u w=5u l=0.28u
X503 VDD a_3225_1460# a_2037_10659.t10 VDD pfet_03v3 ad=1.59p pd=6.53u as=1.59p ps=6.53u w=6u l=0.56u
X504 VDD a_3849_72329.t24 a_4409_62080.t5 VDD pfet_03v3 ad=1.06p pd=4.53u as=1.06p ps=4.53u w=4u l=2u
X505 a_18940_18046# a_19780_15924# VSS ppolyf_u_1k r_width=1u r_length=10u
X506 VSS NB.t50 a_26880_10659.t19 VSS nfet_03v3 ad=2.12p pd=8.53u as=2.12p ps=8.53u w=8u l=2u
X507 a_35349_11849# a_35349_62080.t16 cap_mim_2f0_m4m5_noshield c_width=52.2u c_length=52.2u
X508 a_39480_10659.t18 a_39873_10449# a_2037_15740.t13 VSS nfet_03v3 ad=1.325p pd=5.53u as=1.325p ps=5.53u w=5u l=0.28u
X509 a_45120_18046# a_45960_15924# VSS ppolyf_u_1k r_width=1u r_length=10u
X510 a_34760_18046# a_33920_15924# VSS ppolyf_u_1k r_width=1u r_length=10u
X511 a_22720_18046# a_23560_15924# VSS ppolyf_u_1k r_width=1u r_length=10u
X512 a_35349_66700.t8 a_35349_66700.t7 VDD VDD pfet_03v3 ad=1.06p pd=4.53u as=1.78p ps=8.89u w=4u l=2u
X513 a_12360_18046# a_11520_15924# VSS ppolyf_u_1k r_width=1u r_length=10u
X514 a_1545_5800.t1 a_1427_6669.t3 a_10640_5800.t5 VSS nfet_03v3 ad=0.89p pd=4.89u as=0.89p ps=4.89u w=2u l=0.28u
X515 VDD a_3080_5800.t6 a_3080_5800.t5 VDD pfet_03v3 ad=1.59p pd=6.53u as=1.59p ps=6.53u w=6u l=0.56u
X516 a_39480_10659.t4 NB.t113 VSS VSS nfet_03v3 ad=2.12p pd=8.53u as=2.12p ps=8.53u w=8u l=2u
X517 VSS VTN.t52 a_5421_76080# VSS nfet_03v3 ad=2.12p pd=8.53u as=2.12p ps=8.53u w=8u l=2u
X518 a_31080_10659.t9 NB.t67 VSS VSS nfet_03v3 ad=2.12p pd=8.53u as=2.12p ps=8.53u w=8u l=2u
X519 VDD a_4409_62080.t15 a_4409_62080.t14 VDD pfet_03v3 ad=1.78p pd=8.89u as=1.06p ps=4.53u w=4u l=2u
X520 VSS NB.t22 a_39480_10659.t13 VSS nfet_03v3 ad=2.12p pd=8.53u as=2.12p ps=8.53u w=8u l=2u
X521 a_14040_18046# a_14880_15924# VSS ppolyf_u_1k r_width=1u r_length=10u
X522 VSS NB.t92 a_31080_10659.t6 VSS nfet_03v3 ad=2.12p pd=8.53u as=2.12p ps=8.53u w=8u l=2u
X523 a_11549_11989.t1 G1B.t1 a_1400_1460.t27 VSS nfet_03v3 ad=0.89p pd=4.89u as=0.89p ps=4.89u w=2u l=0.28u
X524 a_35280_10659.t0 a_35673_10449# a_2037_10659.t16 VSS nfet_03v3 ad=1.325p pd=5.53u as=1.325p ps=5.53u w=5u l=0.28u
X525 a_55060_18046# a_54220_15924# VSS ppolyf_u_1k r_width=1u r_length=10u
X526 a_26880_10659.t0 a_16140_15924# a_11681_10659.t15 VSS nfet_03v3 ad=1.325p pd=5.53u as=1.325p ps=5.53u w=5u l=0.28u
X527 VDD a_1400_1460.t57 OUTN.t0 VDD pfet_03v3 ad=1.59p pd=6.53u as=1.59p ps=6.53u w=6u l=0.56u
X528 a_31080_10659.t2 NB.t133 VSS VSS nfet_03v3 ad=2.12p pd=8.53u as=2.12p ps=8.53u w=8u l=2u
X529 a_2037_15740.t12 a_39873_10449# a_39480_10659.t24 VSS nfet_03v3 ad=1.325p pd=5.53u as=1.325p ps=5.53u w=5u l=0.28u
X530 a_11681_10659.t15 a_16140_15924# a_26880_10659.t4 VSS nfet_03v3 ad=1.325p pd=5.53u as=1.325p ps=5.53u w=5u l=0.28u
X531 VDD OUTN.t11 OUTN.t10 VDD pfet_03v3 ad=1.59p pd=6.53u as=1.59p ps=6.53u w=6u l=0.56u
X532 a_1601_10659.t16 a_35349_11849# a_35280_10659.t0 VSS nfet_03v3 ad=1.325p pd=5.53u as=1.325p ps=5.53u w=5u l=0.28u
X533 a_56740_18046# a_43749_11849# VSS ppolyf_u_1k r_width=1u r_length=10u
X534 VDD a_1400_1460.t45 OUTP.t6 VDD pfet_03v3 ad=1.59p pd=6.53u as=1.59p ps=6.53u w=6u l=0.56u
X535 a_3080_5800.t14 a_26920_15924# a_31080_10659.t16 VSS nfet_03v3 ad=1.325p pd=5.53u as=1.325p ps=5.53u w=5u l=0.28u
X536 a_46380_18046# a_45540_15924# VSS ppolyf_u_1k r_width=1u r_length=10u
X537 a_34340_18046# a_35180_15924# VSS ppolyf_u_1k r_width=1u r_length=10u
X538 a_1400_1460.t38 VDD cap_mim_2f0_m4m5_noshield c_width=40u c_length=40u
X539 a_35349_66700.t4 a_34929_67569.t20 VDD VDD pfet_03v3 ad=1.06p pd=4.53u as=1.06p ps=4.53u w=4u l=2u
X540 a_34929_67569.t0 a_35349_66700.t28 VDD VDD pfet_03v3 ad=1.06p pd=4.53u as=1.78p ps=8.89u w=4u l=2u
X541 a_35349_62080.t10 a_35349_62080.t7 VDD VDD pfet_03v3 ad=1.06p pd=4.53u as=1.06p ps=4.53u w=4u l=2u
X542 a_37373_76080# VTN.t13 VSS VSS nfet_03v3 ad=2.12p pd=8.53u as=2.12p ps=8.53u w=8u l=2u
X543 VDD a_34789_72329.t31 a_35349_62080.t7 VDD pfet_03v3 ad=1.06p pd=4.53u as=1.06p ps=4.53u w=4u l=2u
X544 VDD a_12117_10659.t4 a_12117_10659.t3 VDD pfet_03v3 ad=1.59p pd=6.53u as=1.59p ps=6.53u w=6u l=0.56u
X545 a_39480_10659.t19 a_39549_11849# a_1601_15740.t11 VSS nfet_03v3 ad=1.325p pd=5.53u as=1.325p ps=5.53u w=5u l=0.28u
X546 a_1601_15740.t2 a_1400_1460.t54 VDD VDD pfet_03v3 ad=1.59p pd=6.53u as=1.59p ps=6.53u w=6u l=0.56u
X547 a_43680_10659.t8 NB.t99 VSS VSS nfet_03v3 ad=2.12p pd=8.53u as=2.12p ps=8.53u w=8u l=2u
X548 a_35349_66700.t0 a_3080_5800.t19 a_35349_76080# VSS nfet_03v3 ad=0.795p pd=3.53u as=1.335p ps=6.89u w=3u l=1u
X549 VDD a_3225_1460# a_2037_10659.t12 VDD pfet_03v3 ad=1.59p pd=6.53u as=1.59p ps=6.53u w=6u l=0.56u
X550 VSS VTN.t30 a_35349_76080# VSS nfet_03v3 ad=2.12p pd=8.53u as=2.12p ps=8.53u w=8u l=2u
X551 a_12117_10659.t9 a_16560_15924# a_26880_10659.t2 VSS nfet_03v3 ad=1.325p pd=5.53u as=1.325p ps=5.53u w=5u l=0.28u
X552 VSS NB.t148 a_26880_10659.t10 VSS nfet_03v3 ad=2.12p pd=8.53u as=2.12p ps=8.53u w=8u l=2u
X553 a_2037_10659.t10 a_3225_1460# VDD VDD pfet_03v3 ad=1.59p pd=6.53u as=1.59p ps=6.53u w=6u l=0.56u
X554 a_31080_10659.t22 a_26920_15924# a_3080_5800.t15 VSS nfet_03v3 ad=1.325p pd=5.53u as=1.325p ps=5.53u w=5u l=0.28u
X555 VDD a_2037_10659.t2 a_2037_10659.t1 VDD pfet_03v3 ad=1.59p pd=6.53u as=1.59p ps=6.53u w=6u l=0.56u
X556 a_6433_76080# a_3989_67569.t24 a_3849_72329.t0 VSS nfet_03v3 ad=0.795p pd=3.53u as=0.795p ps=3.53u w=3u l=1u
X557 a_35349_76080# VTN.t9 VSS VSS nfet_03v3 ad=2.12p pd=8.53u as=2.12p ps=8.53u w=8u l=2u
X558 a_3989_67569.t11 a_3989_67569.t10 VDD VDD pfet_03v3 ad=1.06p pd=4.53u as=1.06p ps=4.53u w=4u l=2u
X559 VDD a_35349_62080.t7 a_34789_72329.t6 VDD pfet_03v3 ad=1.78p pd=8.89u as=1.06p ps=4.53u w=4u l=2u
X560 a_35280_10659.t0 a_35673_10449# a_2037_10659.t16 VSS nfet_03v3 ad=1.325p pd=5.53u as=1.325p ps=5.53u w=5u l=0.28u
X561 a_35280_10659.t8 NB.t95 VSS VSS nfet_03v3 ad=2.12p pd=8.53u as=2.12p ps=8.53u w=8u l=2u
X562 a_4409_62080.t1 a_3849_72329.t1 VDD VDD pfet_03v3 ad=1.06p pd=4.53u as=1.78p ps=8.89u w=4u l=2u
X563 a_26880_10659.t1 a_16560_15924# a_12117_10659.t9 VSS nfet_03v3 ad=1.325p pd=5.53u as=1.325p ps=5.53u w=5u l=0.28u
X564 a_3080_5800.t2 a_3080_5800.t1 VDD VDD pfet_03v3 ad=1.59p pd=6.53u as=1.59p ps=6.53u w=6u l=0.56u
X565 a_5421_76080# a_3849_72329.t26 a_4409_66700.t12 VSS nfet_03v3 ad=0.795p pd=3.53u as=0.795p ps=3.53u w=3u l=1u
X566 a_4409_76080# VTN.t63 VSS VSS nfet_03v3 ad=2.12p pd=8.53u as=3.56p ps=16.89u w=8u l=2u
X567 a_39345_5800# G1A.t5 a_11681_10659.t2 VDD pfet_03v3 ad=1.78p pd=8.89u as=1.78p ps=8.89u w=4u l=0.28u
X568 a_35349_62080.t5 a_35349_62080.t4 VDD VDD pfet_03v3 ad=1.06p pd=4.53u as=1.06p ps=4.53u w=4u l=2u
X569 VDD a_35349_66700.t23 a_34929_67569.t1 VDD pfet_03v3 ad=1.06p pd=4.53u as=1.06p ps=4.53u w=4u l=2u
X570 a_26880_10659.t13 NB.t119 VSS VSS nfet_03v3 ad=2.12p pd=8.53u as=3.56p ps=16.89u w=8u l=2u
X571 a_2037_10659.t8 a_1905_10449# VDD VDD pfet_03v3 ad=1.59p pd=6.53u as=1.59p ps=6.53u w=6u l=0.56u
X572 a_4409_62080.t0 a_4409_66700.t29 a_6433_76080# VSS nfet_03v3 ad=0.795p pd=3.53u as=0.795p ps=3.53u w=3u l=1u
X573 a_40080_18046# a_40920_15924# VSS ppolyf_u_1k r_width=1u r_length=10u
X574 VDD a_3989_67569.t20 a_4409_66700.t16 VDD pfet_03v3 ad=1.78p pd=8.89u as=1.06p ps=4.53u w=4u l=2u
X575 a_1427_6669.t0 G2A.t5 VSS VSS nfet_03v3 ad=1.78p pd=8.89u as=1.78p ps=8.89u w=4u l=1u
X576 VDD a_1400_1460.t51 a_2037_15740.t0 VDD pfet_03v3 ad=1.59p pd=6.53u as=1.59p ps=6.53u w=6u l=0.56u
X577 a_43680_10659.t17 NB.t9 VSS VSS nfet_03v3 ad=2.12p pd=8.53u as=2.12p ps=8.53u w=8u l=2u
X578 VDD a_10640_5800.t13 a_10640_5800.t12 VDD pfet_03v3 ad=2.67p pd=12.89u as=1.59p ps=6.53u w=6u l=0.56u
X579 a_2037_15740.t14 a_39873_10449# a_39480_10659.t21 VSS nfet_03v3 ad=1.325p pd=5.53u as=1.325p ps=5.53u w=5u l=0.28u
X580 VDD OUTN.t14 OUTN.t13 VDD pfet_03v3 ad=2.67p pd=12.89u as=1.59p ps=6.53u w=6u l=0.56u
X581 a_3780_71559# a_3849_72329.t1 a_3849_72329.t1 VSS nfet_03v3 ad=0.795p pd=3.53u as=0.795p ps=3.53u w=3u l=1u
X582 a_11681_10659.t16 a_16140_15924# a_26880_10659.t6 VSS nfet_03v3 ad=1.325p pd=5.53u as=1.325p ps=5.53u w=5u l=0.28u
X583 a_2037_15740.t0 a_1400_1460.t60 VDD VDD pfet_03v3 ad=1.59p pd=6.53u as=1.59p ps=6.53u w=6u l=0.56u
X584 a_6433_76080# VTN.t59 VSS VSS nfet_03v3 ad=2.12p pd=8.53u as=2.12p ps=8.53u w=8u l=2u
X585 a_3107_2049.t1 G3B.t4 VDD VDD pfet_03v3 ad=1.78p pd=8.89u as=1.78p ps=8.89u w=4u l=1u
X586 a_35349_66700.t19 a_34789_72329.t34 a_36361_76080# VSS nfet_03v3 ad=0.795p pd=3.53u as=1.335p ps=6.89u w=3u l=1u
X587 a_3080_5800.t14 a_26920_15924# a_31080_10659.t18 VSS nfet_03v3 ad=1.325p pd=5.53u as=1.325p ps=5.53u w=5u l=0.28u
X588 OUTN.t10 OUTN.t9 VDD VDD pfet_03v3 ad=1.59p pd=6.53u as=2.67p ps=12.89u w=6u l=0.56u
X589 a_31080_10659.t23 a_26500_15924# a_10640_5800.t17 VSS nfet_03v3 ad=2.225p pd=10.89u as=1.325p ps=5.53u w=5u l=0.28u
X590 a_50020_18046# a_1400_1460.t14 VSS ppolyf_u_1k r_width=1u r_length=10u
X591 OUTP.t7 a_1400_1460.t48 VDD VDD pfet_03v3 ad=1.59p pd=6.53u as=1.59p ps=6.53u w=6u l=0.56u
X592 VSS VTN.t40 a_4409_76080# VSS nfet_03v3 ad=2.12p pd=8.53u as=2.12p ps=8.53u w=8u l=2u
X593 a_4409_66700.t18 a_3989_67569.t13 VDD VDD pfet_03v3 ad=1.06p pd=4.53u as=1.06p ps=4.53u w=4u l=2u
X594 a_37373_76080# a_34929_67569.t23 a_34789_72329.t0 VSS nfet_03v3 ad=0.795p pd=3.53u as=0.795p ps=3.53u w=3u l=1u
X595 a_39480_10659.t20 a_39873_10449# a_2037_15740.t12 VSS nfet_03v3 ad=1.325p pd=5.53u as=1.325p ps=5.53u w=5u l=0.28u
X596 VDD a_4409_66700.t6 a_4409_66700.t7 VDD pfet_03v3 ad=1.06p pd=4.53u as=1.06p ps=4.53u w=4u l=2u
X597 VSS NB.t0 a_26880_10659.t24 VSS nfet_03v3 ad=3.56p pd=16.89u as=2.12p ps=8.53u w=8u l=2u
X598 a_4409_66700.t15 a_3989_67569.t23 VDD VDD pfet_03v3 ad=1.06p pd=4.53u as=1.78p ps=8.89u w=4u l=2u
X599 a_35280_10659.t17 NB.t5 VSS VSS nfet_03v3 ad=2.12p pd=8.53u as=2.12p ps=8.53u w=8u l=2u
X600 a_12117_10659.t3 a_12117_10659.t2 VDD VDD pfet_03v3 ad=1.59p pd=6.53u as=1.59p ps=6.53u w=6u l=0.56u
X601 VDD a_1400_1460.t55 OUTP.t14 VDD pfet_03v3 ad=1.59p pd=6.53u as=1.59p ps=6.53u w=6u l=0.56u
X602 a_26880_10659.t2 a_16140_15924# a_11681_10659.t15 VSS nfet_03v3 ad=1.325p pd=5.53u as=1.325p ps=5.53u w=5u l=0.28u
X603 a_39480_10659.t14 NB.t17 VSS VSS nfet_03v3 ad=2.12p pd=8.53u as=2.12p ps=8.53u w=8u l=2u
X604 a_51700_18046# a_52540_15924# VSS ppolyf_u_1k r_width=1u r_length=10u
X605 a_2037_10659.t12 a_3225_1460# VDD VDD pfet_03v3 ad=1.59p pd=6.53u as=1.59p ps=6.53u w=6u l=0.56u
X606 a_41340_18046# a_40500_15924# VSS ppolyf_u_1k r_width=1u r_length=10u
X607 a_29300_18046# a_30140_15924# VSS ppolyf_u_1k r_width=1u r_length=10u
X608 a_26880_10659.t18 NB.t69 VSS VSS nfet_03v3 ad=2.12p pd=8.53u as=2.12p ps=8.53u w=8u l=2u
X609 VDD a_3849_72329.t8 a_3849_72329.t7 VDD pfet_03v3 ad=1.78p pd=8.89u as=1.06p ps=4.53u w=4u l=2u
X610 VSS NB.t24 a_35280_10659.t15 VSS nfet_03v3 ad=2.12p pd=8.53u as=2.12p ps=8.53u w=8u l=2u
X611 a_1905_10449# G3A.t2 a_2037_10659.t9 VDD pfet_03v3 ad=1.78p pd=8.89u as=1.78p ps=8.89u w=4u l=0.28u
X612 VSS VTN.t36 a_6433_76080# VSS nfet_03v3 ad=2.12p pd=8.53u as=2.12p ps=8.53u w=8u l=2u
X613 VDD a_3849_72329.t22 a_4409_62080.t4 VDD pfet_03v3 ad=1.78p pd=8.89u as=1.06p ps=4.53u w=4u l=2u
X614 VDD a_1545_1460# a_1601_10659.t10 VDD pfet_03v3 ad=1.59p pd=6.53u as=1.59p ps=6.53u w=6u l=0.56u
X615 VSS NB.t36 a_31080_10659.t12 VSS nfet_03v3 ad=2.12p pd=8.53u as=2.12p ps=8.53u w=8u l=2u
X616 a_31080_10659.t21 a_26500_15924# a_10640_5800.t16 VSS nfet_03v3 ad=1.325p pd=5.53u as=1.325p ps=5.53u w=5u l=0.28u
X617 VSS NB.t94 a_35280_10659.t8 VSS nfet_03v3 ad=2.12p pd=8.53u as=2.12p ps=8.53u w=8u l=2u
X618 a_2037_10659.t1 a_2037_10659.t0 VDD VDD pfet_03v3 ad=1.59p pd=6.53u as=1.59p ps=6.53u w=6u l=0.56u
X619 a_1400_1460.t34 a_1400_1460.t33 VDD VDD pfet_03v3 ad=1.59p pd=6.53u as=2.67p ps=12.89u w=6u l=0.56u
X620 VSS NB.t48 a_43680_10659.t13 VSS nfet_03v3 ad=2.12p pd=8.53u as=2.12p ps=8.53u w=8u l=2u
X621 a_1601_10659.t0 a_1469_11989.t4 VDD VDD pfet_03v3 ad=1.59p pd=6.53u as=2.67p ps=12.89u w=6u l=0.56u
X622 a_43020_18046# a_43860_15924# VSS ppolyf_u_1k r_width=1u r_length=10u
X623 a_39345_5800# a_39227_6389# a_1400_1460.t0 VDD pfet_03v3 ad=1.78p pd=8.89u as=1.78p ps=8.89u w=4u l=0.28u
X624 a_26880_10659.t3 a_16560_15924# a_12117_10659.t9 VSS nfet_03v3 ad=1.325p pd=5.53u as=1.325p ps=5.53u w=5u l=0.28u
X625 a_32660_18046# a_31820_15924# VSS ppolyf_u_1k r_width=1u r_length=10u
X626 a_20620_18046# a_21460_15924# VSS ppolyf_u_1k r_width=1u r_length=10u
X627 a_10260_18046# a_9420_15924# VSS ppolyf_u_1k r_width=1u r_length=10u
X628 a_1601_15740.t14 a_39549_11849# a_39480_10659.t22 VSS nfet_03v3 ad=1.325p pd=5.53u as=1.325p ps=5.53u w=5u l=0.28u
X629 VSS NB.t60 a_43680_10659.t11 VSS nfet_03v3 ad=2.12p pd=8.53u as=2.12p ps=8.53u w=8u l=2u
X630 a_43680_10659.t6 NB.t111 VSS VSS nfet_03v3 ad=2.12p pd=8.53u as=2.12p ps=8.53u w=8u l=2u
X631 a_35280_10659.t11 NB.t65 VSS VSS nfet_03v3 ad=2.12p pd=8.53u as=2.12p ps=8.53u w=8u l=2u
X632 a_3080_5800.t14 a_26920_15924# a_31080_10659.t19 VSS nfet_03v3 ad=1.325p pd=5.53u as=1.325p ps=5.53u w=5u l=0.28u
X633 VDD a_10640_5800.t10 a_10640_5800.t9 VDD pfet_03v3 ad=1.59p pd=6.53u as=1.59p ps=6.53u w=6u l=0.56u
X634 VDD a_4409_62080.t23 a_3849_72329.t17 VDD pfet_03v3 ad=1.06p pd=4.53u as=1.06p ps=4.53u w=4u l=2u
X635 a_1545_5800.t2 G2A.t1 a_1400_1460.t22 VSS nfet_03v3 ad=0.89p pd=4.89u as=0.89p ps=4.89u w=2u l=0.28u
X636 a_31080_10659.t8 NB.t77 VSS VSS nfet_03v3 ad=2.12p pd=8.53u as=2.12p ps=8.53u w=8u l=2u
X637 a_23980_18046# a_23140_15924# VSS ppolyf_u_1k r_width=1u r_length=10u
X638 VDD a_1905_10449# a_2037_10659.t7 VDD pfet_03v3 ad=1.59p pd=6.53u as=1.59p ps=6.53u w=6u l=0.56u
X639 a_11940_18046# a_12780_15924# VSS ppolyf_u_1k r_width=1u r_length=10u
X640 VSS NB.t90 a_26880_10659.t15 VSS nfet_03v3 ad=2.12p pd=8.53u as=2.12p ps=8.53u w=8u l=2u
X641 a_35349_66700.t3 a_34929_67569.t22 VDD VDD pfet_03v3 ad=1.06p pd=4.53u as=1.78p ps=8.89u w=4u l=2u
X642 VDD a_35349_66700.t15 a_35349_66700.t14 VDD pfet_03v3 ad=1.06p pd=4.53u as=1.06p ps=4.53u w=4u l=2u
X643 a_35349_62080.t8 a_35349_62080.t7 VDD VDD pfet_03v3 ad=1.06p pd=4.53u as=1.78p ps=8.89u w=4u l=2u
X644 VDD a_12117_10659.t7 a_12117_10659.t6 VDD pfet_03v3 ad=1.59p pd=6.53u as=1.59p ps=6.53u w=6u l=0.56u
X645 a_2037_15740.t0 a_1400_1460.t52 VDD VDD pfet_03v3 ad=1.59p pd=6.53u as=1.59p ps=6.53u w=6u l=0.56u
X646 VDD a_4409_66700.t5 a_4409_66700.t4 VDD pfet_03v3 ad=1.78p pd=8.89u as=1.06p ps=4.53u w=4u l=2u
X647 OUTN.t13 OUTN.t12 VDD VDD pfet_03v3 ad=1.59p pd=6.53u as=1.59p ps=6.53u w=6u l=0.56u
X648 a_31080_10659.t5 NB.t107 VSS VSS nfet_03v3 ad=2.12p pd=8.53u as=2.12p ps=8.53u w=8u l=2u
X649 a_11985_10449.t0 a_45947_6389# a_12117_10659.t1 VSS nfet_03v3 ad=0.89p pd=4.89u as=0.89p ps=4.89u w=2u l=0.28u
X650 a_1601_15740.t2 a_1400_1460.t40 VDD VDD pfet_03v3 ad=1.59p pd=6.53u as=1.59p ps=6.53u w=6u l=0.56u
X651 a_26880_10659.t11 NB.t131 VSS VSS nfet_03v3 ad=2.12p pd=8.53u as=2.12p ps=8.53u w=8u l=2u
X652 a_12117_10659.t10 a_16560_15924# a_26880_10659.t5 VSS nfet_03v3 ad=1.325p pd=5.53u as=1.325p ps=5.53u w=5u l=0.28u
X653 VDD a_1400_1460.t61 a_1601_15740.t2 VDD pfet_03v3 ad=1.59p pd=6.53u as=1.59p ps=6.53u w=6u l=0.56u
X654 a_55480_18046# a_54640_15924# VSS ppolyf_u_1k r_width=1u r_length=10u
X655 a_43440_18046# a_44280_15924# VSS ppolyf_u_1k r_width=1u r_length=10u
X656 a_33080_18046# a_32240_15924# VSS ppolyf_u_1k r_width=1u r_length=10u
X657 VSS VTN.t4 a_37373_76080# VSS nfet_03v3 ad=2.12p pd=8.53u as=2.12p ps=8.53u w=8u l=2u
X658 VDD a_1400_1460.t49 OUTN.t8 VDD pfet_03v3 ad=1.59p pd=6.53u as=1.59p ps=6.53u w=6u l=0.56u
X659 a_39480_10659.t24 a_39873_10449# a_2037_15740.t11 VSS nfet_03v3 ad=1.325p pd=5.53u as=1.325p ps=5.53u w=5u l=0.28u
X660 a_36361_76080# VTN.t11 VSS VSS nfet_03v3 ad=2.12p pd=8.53u as=2.12p ps=8.53u w=8u l=2u
X661 VDD a_34789_72329.t29 a_35349_62080.t7 VDD pfet_03v3 ad=1.78p pd=8.89u as=1.06p ps=4.53u w=4u l=2u
X662 a_26880_10659.t4 a_16560_15924# a_12117_10659.t9 VSS nfet_03v3 ad=1.325p pd=5.53u as=1.325p ps=5.53u w=5u l=0.28u
X663 a_1601_10659.t13 a_1545_1460# VDD VDD pfet_03v3 ad=1.59p pd=6.53u as=1.59p ps=6.53u w=6u l=0.56u
X664 a_1905_10449# a_17789_5800.t4 a_1400_1460.t10 VDD pfet_03v3 ad=1.78p pd=8.89u as=1.78p ps=8.89u w=4u l=0.28u
X665 VSS NB.t122 a_31080_10659.t3 VSS nfet_03v3 ad=2.12p pd=8.53u as=2.12p ps=8.53u w=8u l=2u
X666 a_31080_10659.t16 a_26500_15924# a_10640_5800.t16 VSS nfet_03v3 ad=1.325p pd=5.53u as=1.325p ps=5.53u w=5u l=0.28u
X667 VDD a_11681_10659.t9 a_11681_10659.t8 VDD pfet_03v3 ad=1.59p pd=6.53u as=1.59p ps=6.53u w=6u l=0.56u
X668 a_4409_66700.t1 a_4409_66700.t0 VDD VDD pfet_03v3 ad=1.06p pd=4.53u as=1.78p ps=8.89u w=4u l=2u
X669 a_39480_10659.t3 NB.t127 VSS VSS nfet_03v3 ad=2.12p pd=8.53u as=2.12p ps=8.53u w=8u l=2u
X670 VSS VTN.t28 a_36361_76080# VSS nfet_03v3 ad=2.12p pd=8.53u as=2.12p ps=8.53u w=8u l=2u
X671 a_10640_5800.t16 a_26500_15924# a_31080_10659.t20 VSS nfet_03v3 ad=1.325p pd=5.53u as=1.325p ps=5.53u w=5u l=0.28u
X672 VDD a_3225_1460# a_2037_10659.t11 VDD pfet_03v3 ad=1.59p pd=6.53u as=1.59p ps=6.53u w=6u l=0.56u
X673 a_1601_15740.t11 a_39549_11849# a_39480_10659.t18 VSS nfet_03v3 ad=1.325p pd=5.53u as=1.325p ps=5.53u w=5u l=0.28u
X674 a_39480_10659.t12 NB.t33 VSS VSS nfet_03v3 ad=2.12p pd=8.53u as=2.12p ps=8.53u w=8u l=2u
X675 a_45947_6389# G1B.t4 VDD VDD pfet_03v3 ad=1.78p pd=8.89u as=1.78p ps=8.89u w=4u l=1u
X676 a_1601_10659.t1 a_1469_11989.t4 VDD VDD pfet_03v3 ad=1.59p pd=6.53u as=1.59p ps=6.53u w=6u l=0.56u
X677 a_34789_72329.t13 a_34789_72329.t12 VDD VDD pfet_03v3 ad=1.06p pd=4.53u as=1.06p ps=4.53u w=4u l=2u
X678 a_35349_62080.t2 a_35349_62080.t1 VDD VDD pfet_03v3 ad=1.06p pd=4.53u as=1.78p ps=8.89u w=4u l=2u
X679 a_3225_5800.t0 a_1427_6669.t4 a_1400_1460.t12 VDD pfet_03v3 ad=1.78p pd=8.89u as=1.78p ps=8.89u w=4u l=0.28u
X680 VDD a_34929_67569.t11 a_35349_66700.t5 VDD pfet_03v3 ad=1.06p pd=4.53u as=1.06p ps=4.53u w=4u l=2u
X681 VSS NB.t146 a_31080_10659.t1 VSS nfet_03v3 ad=2.12p pd=8.53u as=2.12p ps=8.53u w=8u l=2u
X682 a_11985_10449.t0 G1B.t0 a_1400_1460.t28 VSS nfet_03v3 ad=0.89p pd=4.89u as=0.89p ps=4.89u w=2u l=0.28u
X683 a_35349_62080.t15 a_34789_72329.t26 VDD VDD pfet_03v3 ad=1.06p pd=4.53u as=1.06p ps=4.53u w=4u l=2u
X684 a_3780_71559# VTN.t47 VSS VSS nfet_03v3 ad=2.12p pd=8.53u as=2.12p ps=8.53u w=8u l=2u
X685 a_34720_71559# VTN.t7 VSS VSS nfet_03v3 ad=2.12p pd=8.53u as=2.12p ps=8.53u w=8u l=2u
X686 a_11681_10659.t15 a_16140_15924# a_26880_10659.t8 VSS nfet_03v3 ad=1.325p pd=5.53u as=2.225p ps=10.89u w=5u l=0.28u
X687 VDD a_1601_10659.t4 a_1601_10659.t3 VDD pfet_03v3 ad=1.59p pd=6.53u as=1.59p ps=6.53u w=6u l=0.56u
X688 VSS NB.t12 a_31080_10659.t14 VSS nfet_03v3 ad=2.12p pd=8.53u as=2.12p ps=8.53u w=8u l=2u
X689 a_3080_5800.t15 a_26920_15924# a_31080_10659.t21 VSS nfet_03v3 ad=1.325p pd=5.53u as=1.325p ps=5.53u w=5u l=0.28u
X690 VSS VTN.t24 a_34720_71559# VSS nfet_03v3 ad=2.12p pd=8.53u as=2.12p ps=8.53u w=8u l=2u
X691 a_10640_5800.t9 a_10640_5800.t8 VDD VDD pfet_03v3 ad=1.59p pd=6.53u as=2.67p ps=12.89u w=6u l=0.56u
X692 VDD a_35349_66700.t21 a_34929_67569.t1 VDD pfet_03v3 ad=1.78p pd=8.89u as=1.06p ps=4.53u w=4u l=2u
X693 OUTP.t6 a_1400_1460.t46 VDD VDD pfet_03v3 ad=1.59p pd=6.53u as=1.59p ps=6.53u w=6u l=0.56u
X694 VSS NB.t142 a_39480_10659.t1 VSS nfet_03v3 ad=2.12p pd=8.53u as=2.12p ps=8.53u w=8u l=2u
X695 a_2037_10659.t4 a_2037_10659.t3 VDD VDD pfet_03v3 ad=1.59p pd=6.53u as=1.59p ps=6.53u w=6u l=0.56u
X696 a_3989_67569.t2 a_4409_66700.t25 VDD VDD pfet_03v3 ad=1.06p pd=4.53u as=1.06p ps=4.53u w=4u l=2u
X697 a_4409_66700.t17 a_3989_67569.t13 VDD VDD pfet_03v3 ad=1.06p pd=4.53u as=1.78p ps=8.89u w=4u l=2u
X698 VDD a_4409_62080.t1 a_3849_72329.t19 VDD pfet_03v3 ad=1.06p pd=4.53u as=1.06p ps=4.53u w=4u l=2u
X699 a_31080_10659.t17 a_26920_15924# a_3080_5800.t14 VSS nfet_03v3 ad=1.325p pd=5.53u as=1.325p ps=5.53u w=5u l=0.28u
X700 a_8580_18046# a_1400_1460.t24 VSS ppolyf_u_1k r_width=1u r_length=10u
X701 a_39227_6389# G1A.t4 VSS VSS nfet_03v3 ad=1.78p pd=8.89u as=1.78p ps=8.89u w=4u l=1u
X702 a_43680_10659.t16 NB.t19 VSS VSS nfet_03v3 ad=2.12p pd=8.53u as=2.12p ps=8.53u w=8u l=2u
X703 VDD a_1545_5800.t6 a_10640_5800.t14 VDD pfet_03v3 ad=1.59p pd=6.53u as=1.59p ps=6.53u w=6u l=0.56u
X704 VDD a_1400_1460.t41 a_2037_15740.t0 VDD pfet_03v3 ad=1.59p pd=6.53u as=1.59p ps=6.53u w=6u l=0.56u
X705 VDD a_1400_1460.t43 OUTN.t5 VDD pfet_03v3 ad=1.59p pd=6.53u as=1.59p ps=6.53u w=6u l=0.56u
X706 a_3780_71559# VTN.t57 VSS VSS nfet_03v3 ad=2.12p pd=8.53u as=2.12p ps=8.53u w=8u l=2u
X707 VSS NB.t72 a_39480_10659.t8 VSS nfet_03v3 ad=2.12p pd=8.53u as=2.12p ps=8.53u w=8u l=2u
X708 VSS VTN.t38 a_3780_71559# VSS nfet_03v3 ad=2.12p pd=8.53u as=2.12p ps=8.53u w=8u l=2u
X709 VDD a_11681_10659.t12 a_11681_10659.t11 VDD pfet_03v3 ad=2.67p pd=12.89u as=1.59p ps=6.53u w=6u l=0.56u
X710 a_1545_5800.t0 a_1427_6669.t5 a_1400_1460.t11 VDD pfet_03v3 ad=1.78p pd=8.89u as=1.78p ps=8.89u w=4u l=0.28u
X711 a_10640_5800.t16 a_26500_15924# a_31080_10659.t24 VSS nfet_03v3 ad=1.325p pd=5.53u as=2.225p ps=10.89u w=5u l=0.28u
X712 OUTN.t8 a_1400_1460.t50 VDD VDD pfet_03v3 ad=1.59p pd=6.53u as=1.59p ps=6.53u w=6u l=0.56u
X713 a_31080_10659.t11 NB.t43 VSS VSS nfet_03v3 ad=2.12p pd=8.53u as=2.12p ps=8.53u w=8u l=2u
X714 VSS VTN.t20 a_36361_76080# VSS nfet_03v3 ad=2.12p pd=8.53u as=2.12p ps=8.53u w=8u l=2u
X715 VDD a_1545_1460# a_1601_10659.t13 VDD pfet_03v3 ad=2.67p pd=12.89u as=1.59p ps=6.53u w=6u l=0.56u
X716 VDD a_3225_1460# a_2037_10659.t13 VDD pfet_03v3 ad=1.59p pd=6.53u as=1.59p ps=6.53u w=6u l=0.56u
X717 a_10640_5800.t17 a_26500_15924# a_31080_10659.t22 VSS nfet_03v3 ad=1.325p pd=5.53u as=1.325p ps=5.53u w=5u l=0.28u
X718 a_35280_10659.t16 NB.t15 VSS VSS nfet_03v3 ad=2.12p pd=8.53u as=2.12p ps=8.53u w=8u l=2u
X719 a_50440_18046# a_1400_1460.t29 VSS ppolyf_u_1k r_width=1u r_length=10u
X720 a_4409_62080.t14 a_4409_62080.t13 VDD VDD pfet_03v3 ad=1.06p pd=4.53u as=1.06p ps=4.53u w=4u l=2u
X721 a_2037_10659.t11 a_3225_1460# VDD VDD pfet_03v3 ad=1.59p pd=6.53u as=1.59p ps=6.53u w=6u l=0.56u
X722 a_1601_10659.t11 a_1545_1460# VDD VDD pfet_03v3 ad=1.59p pd=6.53u as=1.59p ps=6.53u w=6u l=0.56u
X723 VDD a_1601_10659.t7 a_1601_10659.t6 VDD pfet_03v3 ad=2.67p pd=12.89u as=1.59p ps=6.53u w=6u l=0.56u
X724 a_11681_10659.t15 a_16140_15924# a_26880_10659.t1 VSS nfet_03v3 ad=1.325p pd=5.53u as=1.325p ps=5.53u w=5u l=0.28u
X725 VDD a_1905_10449# a_2037_10659.t8 VDD pfet_03v3 ad=1.59p pd=6.53u as=1.59p ps=6.53u w=6u l=0.56u
X726 VSS VTN.t34 a_5421_76080# VSS nfet_03v3 ad=2.12p pd=8.53u as=2.12p ps=8.53u w=8u l=2u
X727 a_26880_10659.t21 NB.t39 VSS VSS nfet_03v3 ad=2.12p pd=8.53u as=3.56p ps=16.89u w=8u l=2u
X728 a_52120_18046# a_52960_15924# VSS ppolyf_u_1k r_width=1u r_length=10u
X729 VSS NB.t46 a_39480_10659.t11 VSS nfet_03v3 ad=2.12p pd=8.53u as=2.12p ps=8.53u w=8u l=2u
X730 a_1601_10659.t3 a_1601_10659.t2 VDD VDD pfet_03v3 ad=1.59p pd=6.53u as=2.67p ps=12.89u w=6u l=0.56u
X731 a_41760_18046# a_40920_15924# VSS ppolyf_u_1k r_width=1u r_length=10u
X732 a_29720_18046# a_30560_15924# VSS ppolyf_u_1k r_width=1u r_length=10u
X733 a_4409_76080# a_12117_10659.t18 a_4409_66700.t11 VSS nfet_03v3 ad=0.795p pd=3.53u as=0.795p ps=3.53u w=3u l=1u
X734 a_34789_72329.t16 a_34789_72329.t15 VDD VDD pfet_03v3 ad=1.06p pd=4.53u as=1.78p ps=8.89u w=4u l=2u
X735 a_31080_10659.t18 a_26500_15924# a_10640_5800.t16 VSS nfet_03v3 ad=1.325p pd=5.53u as=1.325p ps=5.53u w=5u l=0.28u
X736 a_10640_5800.t12 a_10640_5800.t11 VDD VDD pfet_03v3 ad=1.59p pd=6.53u as=1.59p ps=6.53u w=6u l=0.56u
X737 VSS NB.t58 a_43680_10659.t12 VSS nfet_03v3 ad=2.12p pd=8.53u as=2.12p ps=8.53u w=8u l=2u
X738 a_26880_10659.t14 NB.t109 VSS VSS nfet_03v3 ad=2.12p pd=8.53u as=2.12p ps=8.53u w=8u l=2u
X739 a_39480_10659.t9 NB.t63 VSS VSS nfet_03v3 ad=2.12p pd=8.53u as=2.12p ps=8.53u w=8u l=2u
X740 VDD a_4409_62080.t21 a_3849_72329.t18 VDD pfet_03v3 ad=1.78p pd=8.89u as=1.06p ps=4.53u w=4u l=2u
X741 a_36361_76080# a_35349_62080.t25 a_34929_67569.t4 VSS nfet_03v3 ad=1.335p pd=6.89u as=0.795p ps=3.53u w=3u l=1u
X742 a_35280_10659.t10 NB.t75 VSS VSS nfet_03v3 ad=2.12p pd=8.53u as=2.12p ps=8.53u w=8u l=2u
X743 a_21040_18046# a_21880_15924# VSS ppolyf_u_1k r_width=1u r_length=10u
X744 a_10680_18046# a_9840_15924# VSS ppolyf_u_1k r_width=1u r_length=10u
X745 VDD a_1400_1460.t47 OUTP.t7 VDD pfet_03v3 ad=1.59p pd=6.53u as=1.59p ps=6.53u w=6u l=0.56u
X746 a_4409_66700.t19 a_3989_67569.t5 cap_mim_2f0_m4m5_noshield c_width=30.82u c_length=30.82u
X747 VSS NB.t88 a_43680_10659.t9 VSS nfet_03v3 ad=2.12p pd=8.53u as=2.12p ps=8.53u w=8u l=2u
X748 VDD a_35349_66700.t18 a_35349_66700.t17 VDD pfet_03v3 ad=1.78p pd=8.89u as=1.06p ps=4.53u w=4u l=2u
X749 a_31080_10659.t19 a_26920_15924# a_3080_5800.t14 VSS nfet_03v3 ad=1.325p pd=5.53u as=1.325p ps=5.53u w=5u l=0.28u
X750 VDD a_1545_5800.t4 a_10640_5800.t15 VDD pfet_03v3 ad=2.67p pd=12.89u as=1.59p ps=6.53u w=6u l=0.56u
X751 a_39549_11849# a_2037_10659.t17 cap_mim_2f0_m4m5_noshield c_width=52.2u c_length=52.2u
X752 VDD a_3849_72329.t1 a_3849_72329.t9 VDD pfet_03v3 ad=1.06p pd=4.53u as=1.06p ps=4.53u w=4u l=2u
X753 VSS NB.t100 a_43680_10659.t7 VSS nfet_03v3 ad=2.12p pd=8.53u as=2.12p ps=8.53u w=8u l=2u
X754 a_43680_10659.t5 NB.t129 VSS VSS nfet_03v3 ad=2.12p pd=8.53u as=2.12p ps=8.53u w=8u l=2u
X755 a_35280_10659.t7 NB.t105 VSS VSS nfet_03v3 ad=2.12p pd=8.53u as=2.12p ps=8.53u w=8u l=2u
X756 a_45947_6389# G1B.t5 VSS VSS nfet_03v3 ad=1.78p pd=8.89u as=1.78p ps=8.89u w=4u l=1u
X757 a_10785_5800.t2 G2B.t3 a_10640_5800.t6 VDD pfet_03v3 ad=1.78p pd=8.89u as=1.78p ps=8.89u w=4u l=0.28u
X758 OUTN.t5 a_1400_1460.t44 VDD VDD pfet_03v3 ad=1.59p pd=6.53u as=1.59p ps=6.53u w=6u l=0.56u
X759 a_31080_10659.t4 NB.t117 VSS VSS nfet_03v3 ad=2.12p pd=8.53u as=2.12p ps=8.53u w=8u l=2u
X760 a_53380_18046# a_52540_15924# VSS ppolyf_u_1k r_width=1u r_length=10u
X761 a_41340_18046# a_42180_15924# VSS ppolyf_u_1k r_width=1u r_length=10u
X762 a_34789_72329.t10 a_34789_72329.t9 VDD VDD pfet_03v3 ad=1.06p pd=4.53u as=1.78p ps=8.89u w=4u l=2u
X763 VSS VTN.t2 a_36361_76080# VSS nfet_03v3 ad=2.12p pd=8.53u as=2.12p ps=8.53u w=8u l=2u
X764 VSS NB.t78 a_26880_10659.t17 VSS nfet_03v3 ad=2.12p pd=8.53u as=2.12p ps=8.53u w=8u l=2u
X765 a_1601_10659.t10 a_1545_1460# VDD VDD pfet_03v3 ad=1.59p pd=6.53u as=2.67p ps=12.89u w=6u l=0.56u
X766 a_34789_72329.t6 a_35349_62080.t7 VDD VDD pfet_03v3 ad=1.06p pd=4.53u as=1.06p ps=4.53u w=4u l=2u
X767 a_35349_62080.t14 a_34789_72329.t28 VDD VDD pfet_03v3 ad=1.06p pd=4.53u as=1.78p ps=8.89u w=4u l=2u
X768 a_11681_10659.t11 a_11681_10659.t10 VDD VDD pfet_03v3 ad=1.59p pd=6.53u as=1.59p ps=6.53u w=6u l=0.56u
X769 a_3225_1460# G3B.t2 a_2037_10659.t14 VDD pfet_03v3 ad=1.78p pd=8.89u as=1.78p ps=8.89u w=4u l=0.28u
X770 VSS NB.t120 a_26880_10659.t12 VSS nfet_03v3 ad=3.56p pd=16.89u as=2.12p ps=8.53u w=8u l=2u
X771 VSS NB.t14 a_35280_10659.t16 VSS nfet_03v3 ad=2.12p pd=8.53u as=2.12p ps=8.53u w=8u l=2u
X772 a_16560_15924# INN cap_mim_2f0_m4m5_noshield c_width=52.2u c_length=52.2u
X773 a_2037_10659.t13 a_3225_1460# VDD VDD pfet_03v3 ad=1.59p pd=6.53u as=1.59p ps=6.53u w=6u l=0.56u
X774 a_35280_10659.t5 NB.t125 VSS VSS nfet_03v3 ad=2.12p pd=8.53u as=2.12p ps=8.53u w=8u l=2u
X775 VSS VTN.t26 a_37373_76080# VSS nfet_03v3 ad=2.12p pd=8.53u as=2.12p ps=8.53u w=8u l=2u
X776 a_39480_10659.t2 NB.t137 VSS VSS nfet_03v3 ad=2.12p pd=8.53u as=2.12p ps=8.53u w=8u l=2u
X777 VDD a_1545_1460# a_1601_10659.t11 VDD pfet_03v3 ad=1.59p pd=6.53u as=1.59p ps=6.53u w=6u l=0.56u
X778 a_43680_10659.t14 NB.t31 VSS VSS nfet_03v3 ad=2.12p pd=8.53u as=2.12p ps=8.53u w=8u l=2u
X779 a_17789_5800.t0 G3A.t5 VSS VSS nfet_03v3 ad=1.78p pd=8.89u as=1.78p ps=8.89u w=4u l=1u
X780 VDD a_34929_67569.t11 a_35349_66700.t6 VDD pfet_03v3 ad=1.78p pd=8.89u as=1.06p ps=4.53u w=4u l=2u
X781 a_1601_10659.t6 a_1601_10659.t5 VDD VDD pfet_03v3 ad=1.59p pd=6.53u as=1.59p ps=6.53u w=6u l=0.56u
X782 VSS NB.t144 a_35280_10659.t3 VSS nfet_03v3 ad=2.12p pd=8.53u as=2.12p ps=8.53u w=8u l=2u
X783 a_1545_5800.t3 G2A.t3 a_10640_5800.t7 VDD pfet_03v3 ad=1.78p pd=8.89u as=1.78p ps=8.89u w=4u l=0.28u
X784 a_2037_10659.t7 a_1905_10449# VDD VDD pfet_03v3 ad=1.59p pd=6.53u as=1.59p ps=6.53u w=6u l=0.56u
X785 a_6433_76080# VTN.t45 VSS VSS nfet_03v3 ad=2.12p pd=8.53u as=2.12p ps=8.53u w=8u l=2u
X786 a_4409_66700.t16 a_3989_67569.t21 VDD VDD pfet_03v3 ad=1.06p pd=4.53u as=1.06p ps=4.53u w=4u l=2u
X787 a_4409_62080.t18 a_4409_62080.t1 VDD VDD pfet_03v3 ad=1.06p pd=4.53u as=1.06p ps=4.53u w=4u l=2u
X788 VDD a_34789_72329.t20 a_34789_72329.t19 VDD pfet_03v3 ad=1.78p pd=8.89u as=1.06p ps=4.53u w=4u l=2u
X789 a_14145_5800.t1 a_6869_5800.t2 a_3080_5800.t0 VSS nfet_03v3 ad=0.89p pd=4.89u as=0.89p ps=4.89u w=2u l=0.28u
X790 a_31080_10659.t20 a_26920_15924# a_3080_5800.t14 VSS nfet_03v3 ad=1.325p pd=5.53u as=1.325p ps=5.53u w=5u l=0.28u
X791 VSS VTN.t50 a_6433_76080# VSS nfet_03v3 ad=2.12p pd=8.53u as=2.12p ps=8.53u w=8u l=2u
X792 VDD a_3989_67569.t9 a_3989_67569.t8 VDD pfet_03v3 ad=1.06p pd=4.53u as=1.06p ps=4.53u w=4u l=2u
X793 VSS NB.t156 a_31080_10659.t0 VSS nfet_03v3 ad=2.12p pd=8.53u as=2.12p ps=8.53u w=8u l=2u
X794 a_34789_72329.t22 a_34789_72329.t21 a_34720_71559# VSS nfet_03v3 ad=0.795p pd=3.53u as=1.335p ps=6.89u w=3u l=1u
X795 VSS NB.t10 a_26880_10659.t23 VSS nfet_03v3 ad=2.12p pd=8.53u as=2.12p ps=8.53u w=8u l=2u
X796 VDD a_1469_11989.t4 a_1601_10659.t1 VDD pfet_03v3 ad=2.67p pd=12.89u as=1.59p ps=6.53u w=6u l=0.56u
X797 a_34789_72329.t4 a_35349_62080.t22 VDD VDD pfet_03v3 ad=1.06p pd=4.53u as=1.06p ps=4.53u w=4u l=2u
X798 VSS NB.t74 a_35280_10659.t10 VSS nfet_03v3 ad=2.12p pd=8.53u as=2.12p ps=8.53u w=8u l=2u
X799 a_31080_10659.t13 NB.t27 VSS VSS nfet_03v3 ad=2.12p pd=8.53u as=2.12p ps=8.53u w=8u l=2u
X800 OUTN.t6 a_1400_1460.t82 VDD VDD pfet_03v3 ad=1.59p pd=6.53u as=1.59p ps=6.53u w=6u l=0.56u
X801 a_3225_5800.t3 G2A.t0 a_1400_1460.t23 VSS nfet_03v3 ad=0.89p pd=4.89u as=0.89p ps=4.89u w=2u l=0.28u
X802 a_4409_76080# VTN.t41 VSS VSS nfet_03v3 ad=2.12p pd=8.53u as=2.12p ps=8.53u w=8u l=2u
X803 VDD a_4409_62080.t1 a_3849_72329.t20 VDD pfet_03v3 ad=1.78p pd=8.89u as=1.06p ps=4.53u w=4u l=2u
X804 a_10640_5800.t15 a_1545_5800.t5 VDD VDD pfet_03v3 ad=1.59p pd=6.53u as=1.59p ps=6.53u w=6u l=0.56u
X805 a_3080_5800.t17 a_3225_5800.t5 VDD VDD pfet_03v3 ad=1.59p pd=6.53u as=1.59p ps=6.53u w=6u l=0.56u
X806 a_1545_1460# G3B.t3 a_1601_10659.t14 VDD pfet_03v3 ad=1.78p pd=8.89u as=1.78p ps=8.89u w=4u l=0.28u
C0 a_7660_62020# VDD 1.94361f
C1 a_37373_76080# VTN 3.33367f
C2 a_39345_5800# a_58400_15924# 0.01589f
C3 a_35349_11849# OUTP 0.62309f
C4 a_39345_5800# a_40764_5740# 0.01055f
C5 a_49616_62020# VDD 1.94361f
C6 a_30140_15924# a_30560_15924# 0.1684f
C7 a_48458_10360# G1A 0.02959f
C8 VDD a_25460_10599# 1.20662f
C9 a_39345_5800# G3A 0.04369f
C10 VDD a_53816_66640# 1.95466f
C11 a_14460_15924# a_14880_15924# 0.1684f
C12 G3B INN 0.04957f
C13 a_23560_15924# a_24820_15924# 0.01209f
C14 a_16140_15924# a_26080_18046# 0.05138f
C15 a_25956_71260# VDD 1.95466f
C16 a_39345_5800# a_44073_10449# 0.09765f
C17 a_26920_15924# a_27320_15924# 0.07231f
C18 a_36361_76080# VTN 3.48321f
C19 a_6076_62020# VDD 1.94361f
C20 a_16560_15924# G1B 0.03676f
C21 a_29300_18046# a_29720_18046# 0.1684f
C22 a_39345_5800# a_39494_5740# 0.02492f
C23 a_47000_62020# VDD 1.94361f
C24 G2A G3A 2.60676f
C25 VDD a_11308_10599# 1.20662f
C26 G1B a_42705_5800# 0.41135f
C27 a_39227_6389# G1A 1.96301f
C28 VDD a_3225_1460# 7.61706f
C29 VDD a_51200_66640# 1.95466f
C30 a_39345_5800# a_52374_10360# 0.0432f
C31 VDD OUTP 13.9505f
C32 a_23340_71260# VDD 1.95466f
C33 G2B a_42705_5800# 0.03124f
C34 a_45947_6389# a_59798_10360# 0.09782f
C35 a_5054_1400# a_3225_1460# 0.02195f
C36 a_23980_18046# a_24400_18046# 0.1684f
C37 a_26920_15924# a_39873_10449# 1.46157f
C38 a_45416_62020# VDD 1.94361f
C39 a_35673_10449# a_44073_10449# 0.03167f
C40 a_26894_5740# a_1905_10449# 0.04522f
C41 a_47760_10360# G1A 0.03007f
C42 VDD a_13884_5740# 0.58253f
C43 VDD a_21668_10599# 1.20662f
C44 VDD a_5054_5740# 0.58576f
C45 VDD a_49616_66640# 1.95466f
C46 a_39345_5800# a_51964_10360# 0.01627f
C47 VDD a_55734_10360# 0.58366f
C48 a_21756_71260# VDD 1.95466f
C49 a_45947_6389# a_59100_10360# 0.02218f
C50 G2B a_1905_10449# 0.07355f
C51 a_16140_15924# G1B 0.03813f
C52 a_39345_5800# a_43749_11849# 0.04042f
C53 a_4644_1400# a_3225_1460# 0.01055f
C54 a_42800_62020# VDD 1.94361f
C55 a_26484_5740# a_1905_10449# 0.01813f
C56 VDD a_9996_10599# 1.20662f
C57 VDD a_12614_5740# 0.58394f
C58 a_20200_15924# a_21460_15924# 0.01209f
C59 VDD a_4644_5740# 0.58276f
C60 a_34720_71559# a_34460_71499# 0.06437f
C61 a_10260_18046# a_9000_18046# 0.01209f
C62 OUTN a_8180_15924# 0.02462f
C63 VDD a_55324_10360# 0.58259f
C64 a_19140_71260# VDD 1.94361f
C65 a_16140_15924# a_25240_15924# 0.03618f
C66 a_45947_6389# a_57698_10360# 0.09926f
C67 a_26500_15924# a_26920_15924# 0.21056f
C68 a_44534_5740# a_42705_5800# 0.02148f
C69 a_3374_1400# a_3225_1460# 0.02687f
C70 a_26500_15924# a_39873_10449# 1.42771f
C71 a_41216_62020# VDD 1.94361f
C72 a_26920_15924# a_39549_11849# 0.03218f
C73 a_3225_1460# a_1545_1460# 0.448f
C74 a_35349_11849# a_44073_10449# 0.03139f
C75 a_35673_10449# a_43749_11849# 0.02484f
C76 VDD a_7948_10599# 1.20717f
C77 a_25214_5740# a_1905_10449# 0.05118f
C78 a_39549_11849# a_39873_10449# 4.34503f
C79 OUTP a_1545_1460# 0.83684f
C80 G2A INP 0.06346f
C81 VDD a_12204_5740# 0.58253f
C82 G3A a_30958_5740# 0.0248f
C83 VDD a_54054_10360# 0.58394f
C84 a_17556_71260# VDD 1.94361f
C85 a_16140_15924# a_21880_15924# 0.03458f
C86 a_26500_15924# INN 0.21313f
C87 G1A OUTN 0.14008f
C88 a_20620_18046# a_21040_18046# 0.1684f
C89 VDD a_6636_10599# 1.20717f
C90 OUTP a_20280_10599# 0.01654f
C91 VDD a_10934_5740# 0.58329f
C92 G3A a_30260_5740# 0.0248f
C93 G3A VDD 5.03493f
C94 VDD a_53644_10360# 0.58253f
C95 a_57000_10360# a_45947_6389# 0.01625f
C96 a_16140_15924# a_24820_15924# 0.01091f
C97 a_39345_5800# a_72674_37100# 0.04066f
C98 a_18676_66640# VDD 1.95466f
C99 VDD a_44073_10449# 0.89929f
C100 a_71596_22499# a_39345_5800# 0.01494f
C101 a_56740_18046# a_57160_18046# 0.1684f
C102 a_26500_15924# a_39549_11849# 0.03676f
C103 a_6433_76080# a_20244_76020# 0.01968f
C104 G3B a_1905_10449# 0.03327f
C105 a_35349_11849# a_43749_11849# 0.02457f
C106 VDD a_10524_5740# 0.58317f
C107 G3A a_28858_5740# 0.0248f
C108 VDD a_52374_10360# 0.58394f
C109 a_72264_37100# a_72674_37100# 0.0129f
C110 a_16140_15924# a_21460_15924# 0.01087f
C111 a_16560_15924# a_26920_15924# 0.98884f
C112 a_34340_18046# a_34760_18046# 0.1684f
C113 a_13884_5740# a_14294_5740# 0.0129f
C114 a_6433_76080# a_3780_71559# 2.62121f
C115 a_5421_76080# a_20244_76020# 0.01782f
C116 a_16560_15924# a_39873_10449# 0.031f
C117 OUTP a_16488_10599# 0.01654f
C118 a_39345_5800# G2A 0.02931f
C119 VDD a_9118_5740# 1.14186f
C120 a_43564_10599# OUTN 0.01581f
C121 VDD a_51964_10360# 0.58253f
C122 a_72264_37100# a_39345_5800# 0.019f
C123 VDD a_43749_11849# 0.74332f
C124 a_26556_76259# a_6433_76080# 0.06437f
C125 a_16560_15924# INN 7.50152f
C126 a_16560_15924# a_23980_18046# 0.01012f
C127 a_5421_76080# a_3780_71559# 0.60227f
C128 a_35349_76080# a_58756_81719# 0.06437f
C129 OUTN a_3225_1460# 0.03879f
C130 G3A a_1545_1460# 0.2316f
C131 G1A G1B 0.68625f
C132 OUTN OUTP 9.02149f
C133 a_35673_10449# a_37680_15924# 0.03316f
C134 a_39227_6389# G3A 1.33365f
C135 a_42705_5800# a_45947_6389# 0.15844f
C136 G2B G1A 0.10969f
C137 a_16560_15924# a_26500_15924# 3.30407f
C138 G2B a_8420_5740# 0.02148f
C139 a_16140_15924# a_26920_15924# 1.18275f
C140 a_16560_15924# a_23560_15924# 0.05761f
C141 a_24940_76259# a_6433_76080# 0.07909f
C142 a_5421_76080# a_6433_76080# 3.63083f
C143 a_16140_15924# a_39873_10449# 0.18832f
C144 a_16560_15924# a_39549_11849# 0.0312f
C145 OUTP a_15100_10599# 0.01654f
C146 VDD a_7428_39480# 1.22627f
C147 a_41340_18046# a_41760_18046# 0.1684f
C148 OUTN a_9996_10599# 0.019f
C149 a_3780_71559# a_4409_76080# 0.5951f
C150 G2B a_7018_5740# 0.01889f
C151 a_61614_10360# a_61204_10360# 0.0129f
C152 a_31820_15924# a_32240_15924# 0.1684f
C153 a_53380_18046# a_52120_18046# 0.01209f
C154 VDD a_6688_39480# 1.22415f
C155 a_23124_5740# a_23534_5740# 0.0129f
C156 a_4409_76080# a_28516_81719# 0.06437f
C157 a_39227_6389# a_51964_10360# 0.01185f
C158 OUTN a_7948_10599# 0.02219f
C159 a_72674_37100# VDD 0.58576f
C160 a_6433_76080# a_4409_76080# 0.67201f
C161 a_16140_15924# a_26500_15924# 0.52876f
C162 a_23476_76259# a_5421_76080# 0.06437f
C163 a_16560_15924# a_16960_15924# 0.01527f
C164 a_16140_15924# a_23560_15924# 0.03458f
C165 a_71596_22499# VDD 1.20717f
C166 a_16140_15924# a_39549_11849# 0.02657f
C167 a_19780_15924# a_20200_15924# 0.1684f
C168 a_67972_24191# a_67972_22260# 0.01104f
C169 G2A a_2964_5740# 0.01292f
C170 a_35349_11849# a_35673_10449# 2.34625f
C171 G1A a_40080_18046# 0.01139f
C172 OUTP G1B 0.06757f
C173 VDD a_14940_71260# 1.94361f
C174 a_14040_18046# a_15300_18046# 0.01209f
C175 a_37404_5740# a_37814_5740# 0.0129f
C176 a_32364_5740# a_32774_5740# 0.0129f
C177 a_39345_5800# VDD 9.4557f
C178 a_5421_76080# a_4409_76080# 3.5957f
C179 G2B a_3225_1460# 0.06691f
C180 a_69548_22499# VDD 1.20568f
C181 G3A OUTN 0.03507f
C182 INP NB 0.04359f
C183 G2B OUTP 0.04184f
C184 G3B G1A 0.04401f
C185 G2A VDD 4.54691f
C186 OUTN a_44073_10449# 0.27022f
C187 a_16140_15924# a_20200_15924# 0.0364f
C188 VDD a_13356_71260# 1.94361f
C189 G1A a_59798_10360# 0.0248f
C190 a_72264_37100# VDD 0.58308f
C191 VDD a_34044_5740# 0.58253f
C192 a_21860_76259# a_5421_76080# 0.07525f
C193 a_38600_62020# VDD 1.94361f
C194 a_3780_71559# VTN 4.20218f
C195 a_35673_10449# VDD 0.9792f
C196 a_47140_24191# a_47140_22260# 0.01104f
C197 a_47140_28111# NB 0.04725f
C198 a_51700_18046# a_50440_18046# 0.01209f
C199 a_2964_5740# a_3374_5740# 0.0129f
C200 a_54220_15924# a_52960_15924# 0.01209f
C201 VDD a_10740_71260# 1.95466f
C202 G1A a_59100_10360# 0.0248f
C203 VDD a_32774_5740# 0.58394f
C204 a_37016_62020# VDD 1.94361f
C205 VTN a_28516_81719# 0.02656f
C206 a_16140_15924# a_16560_15924# 2.28483f
C207 a_6433_76080# VTN 3.33367f
C208 a_26920_15924# G1A 0.031f
C209 G3A a_28160_5740# 0.0248f
C210 a_21444_5740# a_21854_5740# 0.0129f
C211 OUTN a_43749_11849# 0.48553f
C212 VDD a_53816_62020# 1.95466f
C213 a_43860_15924# a_44280_15924# 0.1684f
C214 a_39873_10449# G1A 1.25774f
C215 a_16140_15924# a_19780_15924# 0.01101f
C216 a_46380_18046# a_44073_10449# 0.01808f
C217 VDD a_9156_71260# 1.95466f
C218 VDD a_3374_5740# 0.58512f
C219 G1A a_57698_10360# 0.0248f
C220 a_39227_6389# a_39345_5800# 0.45054f
C221 VDD a_32364_5740# 0.58253f
C222 a_23140_15924# a_21880_15924# 0.01209f
C223 a_34400_62020# VDD 1.95466f
C224 G2A a_1545_1460# 0.37913f
C225 a_35349_11849# VDD 0.99117f
C226 a_5421_76080# VTN 3.49579f
C227 G3B a_3225_1460# 0.24869f
C228 INN G1A 0.67769f
C229 G3A G1B 1.56673f
C230 a_34044_5740# a_1545_1460# 0.01949f
C231 a_39227_6389# G2A 1.35055f
C232 a_53800_18046# a_53380_18046# 0.1684f
C233 a_26900_81719# a_4409_76080# 0.06925f
C234 a_45960_15924# a_44073_10449# 0.03819f
C235 a_40500_15924# a_40920_15924# 0.1684f
C236 VDD a_6540_71260# 1.95466f
C237 G2B a_6636_10599# 0.01494f
C238 VDD a_2964_5740# 0.5834f
C239 a_35724_5740# a_36134_5740# 0.0129f
C240 G1A a_45947_6389# 0.90006f
C241 G1B a_44073_10449# 0.88072f
C242 a_42180_15924# a_42600_15924# 0.1684f
C243 VDD a_30958_5740# 1.14186f
C244 a_22876_62020# VDD 1.95466f
C245 G2B G3A 6.04597f
C246 a_26500_15924# G1A 0.03633f
C247 a_35673_10449# NB 0.58267f
C248 a_43440_18046# a_44700_18046# 0.01209f
C249 a_32774_5740# a_1545_1460# 0.04261f
C250 a_52540_15924# a_51280_15924# 0.01209f
C251 a_39549_11849# G1A 0.11265f
C252 a_64564_10360# a_64974_10360# 0.0129f
C253 VDD a_1694_5740# 0.58342f
C254 G1A a_57000_10360# 0.0248f
C255 VDD a_30260_5740# 1.22108f
C256 a_20260_62020# VDD 1.94361f
C257 VTN a_4409_76080# 3.92441f
C258 a_50558_10360# VDD 1.14186f
C259 a_22720_18046# a_22300_18046# 0.1684f
C260 G3A a_25214_5740# 0.01118f
C261 a_26920_15924# a_3225_1460# 0.10925f
C262 a_1284_5740# a_1694_5740# 0.0129f
C263 a_34720_71559# a_36076_71499# 0.07881f
C264 a_35349_76080# VDD 0.33039f
C265 a_32364_5740# a_1545_1460# 0.01736f
C266 a_45960_15924# a_43749_11849# 0.03071f
C267 a_26920_15924# OUTP 0.05921f
C268 a_45540_15924# a_44073_10449# 0.01247f
C269 VDD a_1284_5740# 0.58576f
C270 a_13200_15924# a_14460_15924# 0.01209f
C271 a_66654_10360# a_66244_10360# 0.0129f
C272 G1B a_43749_11849# 1.60709f
C273 a_39873_10449# OUTP 0.06224f
C274 a_18676_62020# VDD 1.94361f
C275 a_49860_10360# VDD 1.22108f
C276 G3A a_24804_5740# 0.01505f
C277 a_35349_11849# NB 0.63898f
C278 a_39345_5800# OUTN 0.03598f
C279 VDD a_72534_10360# 0.58576f
C280 INP G1B 0.06303f
C281 a_32240_15924# a_33500_15924# 0.01209f
C282 VTN a_26900_81719# 0.01497f
C283 G2A OUTN 0.60066f
C284 G3A G3B 1.26596f
C285 G2B INP 0.06303f
C286 a_47140_24191# NB 0.04725f
C287 G1A a_70718_10360# 0.0248f
C288 a_16560_15924# G1A 0.03431f
C289 VDD a_15974_5740# 0.58394f
C290 VDD a_1545_1460# 11.1729f
C291 a_26500_15924# OUTP 0.62309f
C292 a_13200_15924# a_12780_15924# 0.1684f
C293 VDD a_72124_10360# 0.58276f
C294 a_35673_10449# OUTN 0.05525f
C295 G1A a_42705_5800# 0.61403f
C296 a_39549_11849# OUTP 0.62309f
C297 a_39227_6389# VDD 1.82038f
C298 a_39227_6389# a_50558_10360# 0.09962f
C299 a_57140_81719# a_35349_76080# 0.06447f
C300 VDD NB 1.05252f
C301 a_8580_18046# a_9000_18046# 0.1684f
C302 G1A a_70020_10360# 0.0248f
C303 VDD a_15564_5740# 0.58253f
C304 VDD a_20280_10599# 1.20662f
C305 a_62884_10360# a_63294_10360# 0.0129f
C306 a_34720_71559# VDD 0.40013f
C307 a_32660_18046# a_33080_18046# 0.1684f
C308 a_39227_6389# a_49860_10360# 0.01668f
C309 a_23140_15924# a_23560_15924# 0.1684f
C310 a_73094_5740# a_1545_1460# 0.01988f
C311 a_34720_71559# a_35349_76080# 0.5951f
C312 G1A a_68618_10360# 0.0248f
C313 a_16140_15924# G1A 2.61643f
C314 a_72124_10360# a_72534_10360# 0.0129f
C315 VDD a_14294_5740# 0.58394f
C316 VDD a_6764_15680# 1.19653f
C317 a_13620_18046# a_12360_18046# 0.01209f
C318 a_35349_11849# OUTN 0.06142f
C319 a_39345_5800# G1B 0.03124f
C320 a_37814_5740# a_3225_1460# 0.04071f
C321 a_36020_18046# a_34760_18046# 0.01209f
C322 a_39227_6389# a_48458_10360# 0.10219f
C323 a_39873_10449# a_44073_10449# 0.42662f
C324 a_35673_10449# a_36440_18046# 0.05175f
C325 a_37373_76080# a_35349_76080# 0.67201f
C326 a_39345_5800# G2B 0.02929f
C327 a_11520_15924# a_12780_15924# 0.01209f
C328 G2A G1B 1.65638f
C329 a_16560_15924# a_3225_1460# 0.11104f
C330 VDD a_1228_15680# 1.19653f
C331 VDD a_16488_10599# 1.20355f
C332 G3B INP 5.82808f
C333 G3A INN 1.39004f
C334 a_37373_76080# a_57496_76259# 0.06437f
C335 a_16560_15924# OUTP 0.05818f
C336 a_37404_5740# a_3225_1460# 0.0153f
C337 G2A G2B 8.16357f
C338 G3A a_45947_6389# 0.38129f
C339 a_15564_5740# a_15974_5740# 0.0129f
C340 a_35673_10449# G1B 0.03849f
C341 a_22720_18046# a_23980_18046# 0.01209f
C342 OUTP a_42705_5800# 0.04358f
C343 a_36361_76080# a_35349_76080# 3.59468f
C344 a_42854_5740# a_42705_5800# 0.02492f
C345 G1A a_67920_10360# 0.0248f
C346 VDD OUTN 13.1619f
C347 VDD a_6764_17191# 1.18979f
C348 a_37373_76080# a_55880_76259# 0.07597f
C349 a_44700_18046# a_45120_18046# 0.1684f
C350 a_30980_18046# a_29720_18046# 0.01209f
C351 a_26920_15924# a_43749_11849# 0.03853f
C352 a_1905_10449# a_3225_1460# 0.41251f
C353 a_36134_5740# a_3225_1460# 0.04271f
C354 a_47760_10360# a_39227_6389# 0.02652f
C355 a_16560_15924# a_23140_15924# 0.01441f
C356 a_1694_1400# a_1545_1460# 0.02661f
C357 a_42705_5800# a_55734_10360# 0.04194f
C358 a_39549_11849# a_44073_10449# 0.02818f
C359 a_39873_10449# a_43749_11849# 0.03289f
C360 a_35349_11849# a_36440_18046# 0.0513f
C361 a_11940_18046# a_12360_18046# 0.1684f
C362 a_37373_76080# a_51184_76020# 0.01968f
C363 VDD a_15100_10599# 1.20375f
C364 a_16140_15924# OUTP 0.62309f
C365 a_35724_5740# a_3225_1460# 0.01479f
C366 a_55480_18046# a_56740_18046# 0.01209f
C367 a_35349_11849# G1B 0.03482f
C368 a_42705_5800# a_55324_10360# 0.01909f
C369 a_36361_76080# a_51184_76020# 0.01279f
C370 a_32660_18046# a_31400_18046# 0.01209f
C371 a_37373_76080# a_34720_71559# 2.62121f
C372 a_36361_76080# a_54416_76259# 0.06437f
C373 a_26500_15924# a_43749_11849# 0.11143f
C374 INP INN 0.06303f
C375 a_16140_15924# a_23140_15924# 0.01087f
C376 a_39549_11849# a_43749_11849# 3.23005f
C377 a_42705_5800# a_54054_10360# 0.04264f
C378 a_35349_11849# a_36020_18046# 0.01166f
C379 OUTN a_1545_1460# 2.11419f
C380 G2A G3B 5.50182f
C381 a_58400_15924# a_42705_5800# 0.01059f
C382 a_36361_76080# a_34720_71559# 0.60227f
C383 VDD a_1228_17191# 1.18979f
C384 a_16560_15924# G3A 0.03791f
C385 VDD a_26894_5740# 0.58394f
C386 VDD G1B 3.17099f
C387 G3A a_42705_5800# 0.02954f
C388 a_16560_15924# a_22720_18046# 0.01139f
C389 a_42705_5800# a_53644_10360# 0.01999f
C390 a_16060_66640# VDD 1.95466f
C391 a_35349_11849# a_35600_15924# 0.05577f
C392 a_41340_18046# a_40080_18046# 0.01209f
C393 a_44073_10449# a_42705_5800# 0.04316f
C394 G3A a_21854_5740# 0.01118f
C395 G2B VDD 4.95238f
C396 a_36361_76080# a_37373_76080# 3.63083f
C397 a_3460_66640# VDD 1.95466f
C398 a_55900_15924# a_56320_15924# 0.1684f
C399 VDD a_26484_5740# 0.58253f
C400 a_56320_15924# a_43749_11849# 0.05457f
C401 a_35180_15924# a_33920_15924# 0.01209f
C402 G3A a_1905_10449# 0.61328f
C403 a_46380_18046# a_45120_18046# 0.01209f
C404 a_39345_5800# a_39873_10449# 0.04119f
C405 a_69324_5740# a_1905_10449# 0.01132f
C406 a_14476_66640# VDD 1.95466f
C407 G3A a_21444_5740# 0.01505f
C408 a_41760_18046# a_39873_10449# 0.01102f
C409 a_56896_71260# VDD 1.95466f
C410 a_16140_15924# G3A 0.03124f
C411 a_46404_10599# OUTN 0.01148f
C412 a_13620_18046# a_14040_18046# 0.1684f
C413 VDD a_25214_5740# 0.58394f
C414 OUTP a_8180_15924# 0.0109f
C415 a_16560_15924# a_43749_11849# 0.98588f
C416 a_16140_15924# a_44073_10449# 0.0347f
C417 a_11860_66640# VDD 1.95466f
C418 a_47140_26151# NB 0.04725f
C419 a_35673_10449# a_39873_10449# 0.03573f
C420 G3A a_20038_5740# 0.02959f
C421 a_54280_71260# VDD 1.95466f
C422 G2A INN 0.0261f
C423 VDD a_24804_5740# 0.58253f
C424 a_39227_6389# G1B 0.05485f
C425 G2A a_45947_6389# 0.22278f
C426 G2B a_1545_1460# 0.07294f
C427 G1A OUTP 0.1082f
C428 a_10276_66640# VDD 1.95466f
C429 NB G1B 1.63373f
C430 G3A a_19340_5740# 0.03007f
C431 a_39227_6389# G2B 0.03017f
C432 VDD a_61204_10360# 0.58253f
C433 a_41340_18046# a_39873_10449# 0.01629f
C434 a_52696_71260# VDD 1.95466f
C435 G3B a_30260_5740# 0.01011f
C436 G3B VDD 2.59859f
C437 a_47000_66640# VDD 1.95466f
C438 a_16140_15924# a_14880_15924# 0.02031f
C439 a_47760_10360# G1B 0.01306f
C440 a_16140_15924# a_43749_11849# 0.02788f
C441 a_42600_15924# a_43860_15924# 0.01209f
C442 a_34340_18046# a_39549_11849# 0.01538f
C443 a_7660_66640# VDD 1.95466f
C444 a_35673_10449# a_39549_11849# 0.03937f
C445 a_35349_11849# a_39873_10449# 0.03546f
C446 VDD a_59798_10360# 1.14186f
C447 a_31820_15924# a_30560_15924# 0.01209f
C448 a_40920_15924# a_39873_10449# 0.04578f
C449 a_50080_71260# VDD 1.94361f
C450 a_45416_66640# VDD 1.95466f
C451 a_16140_15924# INP 6.22555f
C452 G2B a_6764_15680# 0.01623f
C453 a_33920_15924# a_39549_11849# 0.04307f
C454 a_6076_66640# VDD 1.95466f
C455 OUTP a_25460_10599# 0.01654f
C456 VDD a_59100_10360# 1.22108f
C457 a_34400_66640# VDD 1.95466f
C458 a_46380_18046# a_46800_18046# 0.1684f
C459 a_48496_71260# VDD 1.94361f
C460 a_42800_66640# VDD 1.95466f
C461 a_26920_15924# VDD 0.81295f
C462 OUTP a_11308_10599# 0.01654f
C463 a_39873_10449# VDD 0.90987f
C464 a_43020_18046# a_43440_18046# 0.1684f
C465 G1A a_54054_10360# 0.01283f
C466 a_39345_5800# a_42705_5800# 1.54967f
C467 OUTP a_3225_1460# 0.17034f
C468 a_35349_11849# a_39549_11849# 0.04144f
C469 G3B a_1545_1460# 0.72548f
C470 a_43020_18046# a_41760_18046# 0.01209f
C471 a_27076_66640# VDD 1.95466f
C472 OUTN G1B 0.91452f
C473 a_40920_15924# a_39549_11849# 0.01931f
C474 a_46800_18046# G1B 0.01137f
C475 a_41216_66640# VDD 1.95466f
C476 a_10260_18046# a_10680_18046# 0.1684f
C477 G2A a_42705_5800# 0.03126f
C478 G2B OUTN 0.0437f
C479 G2B a_6764_17191# 0.01913f
C480 INN VDD 0.0515f
C481 G3A G1A 4.24254f
C482 a_10680_18046# a_11940_18046# 0.01209f
C483 a_45540_15924# a_44280_15924# 0.01209f
C484 G1A a_53644_10360# 0.01306f
C485 OUTP a_21668_10599# 0.01654f
C486 a_24460_66640# VDD 1.95466f
C487 VDD a_45947_6389# 1.87739f
C488 G2A a_70020_10360# 0.01348f
C489 a_25660_18046# a_26080_18046# 0.1684f
C490 a_3780_71559# a_5136_71499# 0.07881f
C491 a_38600_66640# VDD 1.95466f
C492 G2A a_1905_10449# 0.09502f
C493 a_26500_15924# VDD 0.913f
C494 OUTP a_9996_10599# 0.01654f
C495 a_3780_71559# a_3520_71499# 0.06437f
C496 a_3780_71559# VDD 0.49099f
C497 a_39549_11849# VDD 0.93954f
C498 a_18940_18046# a_19360_18046# 0.1684f
C499 a_22876_66640# VDD 1.95466f
C500 VDD a_65296_15919# 1.20717f
C501 a_26920_15924# a_1545_1460# 0.14728f
C502 a_51700_18046# a_52120_18046# 0.1684f
C503 a_37016_66640# VDD 1.95466f
C504 a_4644_5740# a_5054_5740# 0.0129f
C505 a_35673_10449# a_16140_15924# 2.12709f
C506 a_26920_15924# NB 0.48521f
C507 VDD a_63248_15919# 1.20568f
C508 a_20260_66640# VDD 1.95466f
C509 a_55324_10360# a_55734_10360# 0.0129f
C510 VDD a_23534_5740# 0.58394f
C511 a_36020_18046# a_36440_18046# 0.1684f
C512 G3A a_3225_1460# 0.27522f
C513 G2B G1B 0.10004f
C514 a_34454_5740# a_34044_5740# 0.0129f
C515 INN NB 0.98755f
C516 G3A OUTP 0.03523f
C517 INP G1A 0.06303f
C518 VDD a_61936_15919# 1.20717f
C519 VDD a_4588_10599# 1.20717f
C520 VDD a_37814_5740# 0.58394f
C521 a_39227_6389# a_45947_6389# 0.08676f
C522 G2A a_67920_10360# 0.02281f
C523 a_26500_15924# a_1545_1460# 0.11719f
C524 a_26484_5740# a_26894_5740# 0.0129f
C525 OUTP a_44073_10449# 0.60355f
C526 VDD a_23124_5740# 0.58253f
C527 a_12204_5740# a_12614_5740# 0.0129f
C528 VDD a_70718_10360# 1.14186f
C529 a_16560_15924# VDD 0.8428f
C530 a_35349_11849# a_16140_15924# 0.47834f
C531 a_26500_15924# NB 0.04956f
C532 VDD a_42705_5800# 3.64762f
C533 a_45540_15924# a_45960_15924# 0.1684f
C534 VDD a_3276_10599# 1.20717f
C535 VDD a_37404_5740# 0.58253f
C536 a_50020_18046# a_50440_18046# 0.1684f
C537 a_52540_15924# a_52960_15924# 0.1684f
C538 VDD a_21854_5740# 0.58329f
C539 VDD a_4409_76080# 0.33039f
C540 VDD a_66244_10360# 0.58253f
C541 VDD a_70020_10360# 1.22108f
C542 a_42180_15924# a_40920_15924# 0.01209f
C543 VDD a_36134_5740# 0.58394f
C544 VDD a_59888_15919# 1.20568f
C545 VDD a_1905_10449# 3.8928f
C546 a_26920_15924# OUTN 0.05018f
C547 a_71596_22499# G1A 0.0158f
C548 G3B a_28160_5740# 0.02044f
C549 OUTP a_43749_11849# 0.71851f
C550 VDD a_21444_5740# 0.58317f
C551 a_39873_10449# OUTN 0.05153f
C552 VDD a_64974_10360# 0.58394f
C553 a_9420_15924# a_9840_15924# 0.1684f
C554 a_16140_15924# VDD 1.20599f
C555 a_9840_15924# a_11100_15924# 0.01209f
C556 VDD a_45880_71260# 1.94361f
C557 a_11100_15924# a_11520_15924# 0.1684f
C558 a_39345_5800# G1A 1.61849f
C559 VDD a_35724_5740# 0.58253f
C560 VDD a_1228_10599# 1.20717f
C561 a_53644_10360# a_54054_10360# 0.0129f
C562 G3B G1B 0.04401f
C563 a_16560_15924# a_1545_1460# 0.04068f
C564 a_24820_15924# a_25240_15924# 0.1684f
C565 VDD a_20038_5740# 1.14186f
C566 VDD a_64564_10360# 0.58253f
C567 a_69968_15919# VDD 1.20568f
C568 a_44073_10449# a_58400_15924# 0.01051f
C569 G2A G1A 0.63253f
C570 OUTN a_45947_6389# 0.14407f
C571 G2B G3B 2.90496f
C572 VDD a_44296_71260# 1.94361f
C573 a_16560_15924# NB 0.30223f
C574 a_39227_6389# a_42705_5800# 0.52709f
C575 VDD a_34454_5740# 0.58394f
C576 a_50860_15924# a_51280_15924# 0.1684f
C577 a_26500_15924# OUTN 0.06335f
C578 a_35673_10449# G1A 0.03678f
C579 a_24804_5740# a_25214_5740# 0.0129f
C580 a_15300_18046# a_15720_18046# 0.1684f
C581 VDD a_19340_5740# 1.21149f
C582 a_39549_11849# OUTN 0.06087f
C583 VDD a_63294_10360# 0.58394f
C584 a_24400_18046# a_25660_18046# 0.01209f
C585 a_10524_5740# a_10934_5740# 0.0129f
C586 a_1905_10449# a_1545_1460# 1.27551f
C587 a_48040_15924# G1B 0.05978f
C588 VDD VTN 0.8735f
C589 VDD a_41680_71260# 1.95466f
C590 G1B a_59100_10360# 0.01348f
C591 VDD a_72016_15919# 1.20717f
C592 a_16140_15924# a_1545_1460# 0.09439f
C593 a_35349_76080# VTN 3.80913f
C594 a_54640_15924# a_54220_15924# 0.1684f
C595 a_26500_15924# a_26080_18046# 0.04562f
C596 a_68656_15919# VDD 1.20717f
C597 VDD a_62884_10360# 0.58253f
C598 a_21460_15924# a_21880_15924# 0.1684f
C599 a_26920_15924# G1B 0.03853f
C600 a_16060_62020# VDD 1.94361f
C601 VDD a_66654_10360# 0.58394f
C602 a_71414_5740# a_1905_10449# 0.01993f
C603 a_39873_10449# G1B 0.98488f
C604 a_35180_15924# a_35600_15924# 0.1684f
C605 VDD a_40096_71260# 1.95466f
C606 a_16140_15924# NB 0.59345f
C607 a_36361_76080# a_52800_76259# 0.07525f
C608 a_33920_15924# a_33500_15924# 0.1684f
C609 a_35349_11849# G1A 0.14512f
C610 a_39345_5800# OUTP 0.03332f
C611 a_55060_18046# a_55480_18046# 0.1684f
C612 a_19360_18046# a_20620_18046# 0.01209f
C613 VDD a_61614_10360# 0.58394f
C614 a_40920_15924# G1A 0.04545f
C615 a_14476_62020# VDD 1.94361f
C616 INN G1B 0.04995f
C617 a_43749_11849# a_44073_10449# 7.40865f
C618 a_71004_5740# a_1905_10449# 0.01002f
C619 a_34454_5740# a_1545_1460# 0.04085f
C620 G2A a_6320_5740# 0.01038f
C621 G2A a_3225_1460# 0.07978f
C622 VDD a_37480_71260# 1.95466f
C623 G2A OUTP 0.02045f
C624 G1B a_45947_6389# 1.92116f
C625 G3A INP 0.06303f
C626 G2B INN 0.24466f
C627 a_51964_10360# a_52374_10360# 0.0129f
C628 a_21040_18046# a_22300_18046# 0.01209f
C629 VDD a_3460_62020# 1.95466f
C630 a_16560_15924# OUTN 0.04842f
C631 a_55060_18046# a_53800_18046# 0.01209f
C632 a_26500_15924# a_25660_18046# 0.01185f
C633 a_66608_15919# VDD 1.20568f
C634 G2B a_45947_6389# 0.03556f
C635 a_39549_11849# a_45960_15924# 0.06273f
C636 a_39660_18046# a_40080_18046# 0.1684f
C637 a_26500_15924# G1B 0.0364f
C638 a_11860_62020# VDD 1.94361f
C639 a_35673_10449# OUTP 0.06464f
C640 OUTN a_42705_5800# 0.14906f
C641 a_69734_5740# a_1905_10449# 0.0224f
C642 a_39549_11849# G1B 0.88849f
C643 G1B a_57000_10360# 0.02044f
C644 a_50558_10360# G1A 0.02959f
C645 VDD G1A 8.53281f
C646 VDD a_58016_66640# 1.95466f
C647 VDD a_8420_5740# 1.21149f
C648 a_34340_18046# a_33080_18046# 0.01209f
C649 a_26500_15924# a_25240_15924# 0.02015f
C650 a_40500_15924# G1A 0.01076f
C651 a_34720_71559# VTN 4.20218f
C652 a_39345_5800# a_41174_5740# 0.02195f
C653 a_10276_62020# VDD 1.94361f
C654 a_51200_62020# VDD 1.94361f
C655 a_54640_15924# a_55900_15924# 0.01209f
C656 a_49860_10360# G1A 0.03738f
C657 VDD a_55400_66640# 1.95466f
C658 a_16140_15924# OUTN 0.06252f
C659 a_30980_18046# a_31400_18046# 0.1684f
C660 a_39345_5800# a_51280_15924# 0.05175f
R0 INP INP.t0 188.619
R1 G3B G3B.n4 120.126
R2 G3B.n0 G3B.t2 86.0715
R3 G3B.n0 G3B.t3 81.0555
R4 G3B.n3 G3B.t0 70.6269
R5 G3B.n4 G3B.t1 61.6959
R6 G3B.n3 G3B.n2 51.3485
R7 G3B.n1 G3B.t4 30.2982
R8 G3B.n2 G3B.t5 21.2982
R9 G3B.n4 G3B.n3 13.1525
R10 G3B.n2 G3B.n1 12.1265
R11 G3B.n1 G3B.n0 2.9165
R12 G3A G3A.n4 124.537
R13 G3A.n1 G3A.t2 81.2415
R14 G3A.n2 G3A.t3 81.2415
R15 G3A.n0 G3A.t0 75.8289
R16 G3A.n1 G3A.n0 73.6085
R17 G3A.n0 G3A.t1 70.8129
R18 G3A.n3 G3A.t4 21.2982
R19 G3A.n4 G3A.t5 21.1512
R20 G3A.n3 G3A.n2 12.1025
R21 G3A.n2 G3A.n1 5.0165
R22 G3A.n4 G3A.n3 2.2865
R23 G2B G2B.n4 95.3465
R24 G2B.n1 G2B.t2 81.0555
R25 G2B.n2 G2B.t3 81.0555
R26 G2B.n1 G2B.n0 79.6985
R27 G2B.n0 G2B.t0 76.2489
R28 G2B.n0 G2B.t1 71.2329
R29 G2B.n3 G2B.t4 21.2982
R30 G2B.n4 G2B.t5 21.1512
R31 G2B.n3 G2B.n2 11.9165
R32 G2B.n2 G2B.n1 5.0165
R33 G2B.n4 G2B.n3 2.2865
R34 G2A.n4 G2A.n3 85.8125
R35 G2A.n0 G2A.t3 83.9715
R36 G2A G2A.n4 76.2125
R37 G2A.n4 G2A.t2 72.0555
R38 G2A.n3 G2A.t1 71.0229
R39 G2A.n2 G2A.t0 70.8129
R40 G2A.n2 G2A.n1 31.8185
R41 G2A.n0 G2A.t4 30.2982
R42 G2A.n1 G2A.t5 21.2982
R43 G2A.n1 G2A.n0 12.1265
R44 G2A.n3 G2A.n2 5.2265
R45 G1B G1B.n4 131.49
R46 G1B.n0 G1B.t2 86.0715
R47 G1B.n0 G1B.t3 81.0555
R48 G1B.n3 G1B.t0 70.6269
R49 G1B.n4 G1B.t1 61.6959
R50 G1B.n1 G1B.t4 30.2982
R51 G1B.n3 G1B.n2 25.7285
R52 G1B.n2 G1B.t5 21.2982
R53 G1B.n4 G1B.n3 13.1525
R54 G1B.n2 G1B.n1 12.1265
R55 G1B.n1 G1B.n0 2.9165
R56 OUTP OUTP.n10 83.1755
R57 OUTP.n10 OUTP.n0 57.6065
R58 OUTP.n6 OUTP.t5 57.0573
R59 OUTP.n7 OUTP.t0 57.0573
R60 OUTP.n6 OUTP.t3 49.471
R61 OUTP.n7 OUTP.t2 49.471
R62 OUTP.n0 OUTP.n5 21.7625
R63 OUTP.n10 OUTP.n1 9.6065
R64 OUTP.n0 OUTP.n8 7.83567
R65 OUTP.n2 OUTP.t14 7.08881
R66 OUTP.n5 OUTP.n4 6.7865
R67 OUTP.n3 OUTP.t8 5.74412
R68 OUTP.n4 OUTP.t13 5.38626
R69 OUTP.n2 OUTP.t6 5.32952
R70 OUTP.n3 OUTP.t15 5.27698
R71 OUTP.n2 OUTP.t7 5.22024
R72 OUTP.n0 OUTP.n9 4.8965
R73 OUTP.n5 OUTP.n2 4.85836
R74 OUTP.n8 OUTP.n7 3.79364
R75 OUTP.n8 OUTP.n6 3.79364
R76 OUTP.n1 OUTP.t11 3.5234
R77 OUTP.n1 OUTP.t12 3.40849
R78 OUTP.n9 OUTP.t4 3.16755
R79 OUTP.n1 OUTP.t9 3.1634
R80 OUTP.n1 OUTP.t10 3.14813
R81 OUTP.n9 OUTP.t1 3.00041
R82 OUTP.n4 OUTP.n3 1.75979
R83 OUTN OUTN.n11 131.055
R84 OUTN.n7 OUTN.t14 58.4912
R85 OUTN.n8 OUTN.t9 58.4912
R86 OUTN.n11 OUTN.n1 57.8165
R87 OUTN.n7 OUTN.t12 50.905
R88 OUTN.n8 OUTN.t11 50.905
R89 OUTN.n9 OUTN.n8 34.9976
R90 OUTN.n9 OUTN.n7 34.9976
R91 OUTN.n1 OUTN.n6 19.8725
R92 OUTN.n11 OUTN.n0 9.8165
R93 OUTN.n4 OUTN.t0 6.81644
R94 OUTN.n6 OUTN.n3 6.7865
R95 OUTN.n2 OUTN.t6 6.40449
R96 OUTN.n1 OUTN.n9 5.96988
R97 OUTN.n1 OUTN.n10 5.7125
R98 OUTN.n3 OUTN.t7 5.12949
R99 OUTN.n5 OUTN.t5 5.0743
R100 OUTN.n2 OUTN.t15 5.00306
R101 OUTN.n4 OUTN.t8 4.94787
R102 OUTN.n6 OUTN.n5 4.5005
R103 OUTN.n0 OUTN.t3 3.61568
R104 OUTN.n0 OUTN.t1 3.25809
R105 OUTN.n10 OUTN.t13 3.23546
R106 OUTN.n0 OUTN.t2 3.03068
R107 OUTN.n0 OUTN.t4 2.99774
R108 OUTN.n10 OUTN.t10 2.73081
R109 OUTN.n3 OUTN.n2 1.74264
R110 OUTN.n5 OUTN.n4 1.2755
R111 G1A.n0 G1A.t5 149.257
R112 G1A G1A.n4 108.576
R113 G1A.n0 G1A.t2 81.2415
R114 G1A.n3 G1A.t0 70.8129
R115 G1A.n4 G1A.t1 61.6959
R116 G1A.n1 G1A.t3 30.4842
R117 G1A.n3 G1A.n2 22.1585
R118 G1A.n2 G1A.t4 21.2982
R119 G1A.n4 G1A.n3 13.3385
R120 G1A.n2 G1A.n1 12.3125
R121 G1A.n1 G1A.n0 5.4365
R122 NB.n160 NB.n159 107.508
R123 NB NB.n160 57.6005
R124 NB.n1 NB.t0 36.0256
R125 NB.n20 NB.t39 36.0256
R126 NB.n40 NB.t40 34.3534
R127 NB.n59 NB.t79 34.3534
R128 NB.n80 NB.t80 34.3534
R129 NB.n99 NB.t119 34.3534
R130 NB.n120 NB.t120 34.3534
R131 NB.n139 NB.t159 34.3534
R132 NB.n160 NB.n0 31.6506
R133 NB.n0 NB.t160 25.3131
R134 NB.n0 NB.t161 25.3131
R135 NB.n19 NB.n18 21.4256
R136 NB.n18 NB.n17 21.4256
R137 NB.n17 NB.n16 21.4256
R138 NB.n16 NB.n15 21.4256
R139 NB.n15 NB.n14 21.4256
R140 NB.n14 NB.n13 21.4256
R141 NB.n13 NB.n12 21.4256
R142 NB.n12 NB.n11 21.4256
R143 NB.n11 NB.n10 21.4256
R144 NB.n10 NB.n9 21.4256
R145 NB.n9 NB.n8 21.4256
R146 NB.n8 NB.n7 21.4256
R147 NB.n7 NB.n6 21.4256
R148 NB.n6 NB.n5 21.4256
R149 NB.n5 NB.n4 21.4256
R150 NB.n4 NB.n3 21.4256
R151 NB.n3 NB.n2 21.4256
R152 NB.n2 NB.n1 21.4256
R153 NB.n38 NB.n37 21.4256
R154 NB.n37 NB.n36 21.4256
R155 NB.n36 NB.n35 21.4256
R156 NB.n35 NB.n34 21.4256
R157 NB.n34 NB.n33 21.4256
R158 NB.n33 NB.n32 21.4256
R159 NB.n32 NB.n31 21.4256
R160 NB.n31 NB.n30 21.4256
R161 NB.n30 NB.n29 21.4256
R162 NB.n29 NB.n28 21.4256
R163 NB.n28 NB.n27 21.4256
R164 NB.n27 NB.n26 21.4256
R165 NB.n26 NB.n25 21.4256
R166 NB.n25 NB.n24 21.4256
R167 NB.n24 NB.n23 21.4256
R168 NB.n23 NB.n22 21.4256
R169 NB.n22 NB.n21 21.4256
R170 NB.n21 NB.n20 21.4256
R171 NB.n58 NB.n57 19.7534
R172 NB.n57 NB.n56 19.7534
R173 NB.n56 NB.n55 19.7534
R174 NB.n55 NB.n54 19.7534
R175 NB.n54 NB.n53 19.7534
R176 NB.n53 NB.n52 19.7534
R177 NB.n52 NB.n51 19.7534
R178 NB.n51 NB.n50 19.7534
R179 NB.n50 NB.n49 19.7534
R180 NB.n49 NB.n48 19.7534
R181 NB.n48 NB.n47 19.7534
R182 NB.n47 NB.n46 19.7534
R183 NB.n46 NB.n45 19.7534
R184 NB.n45 NB.n44 19.7534
R185 NB.n44 NB.n43 19.7534
R186 NB.n43 NB.n42 19.7534
R187 NB.n42 NB.n41 19.7534
R188 NB.n41 NB.n40 19.7534
R189 NB.n77 NB.n76 19.7534
R190 NB.n76 NB.n75 19.7534
R191 NB.n75 NB.n74 19.7534
R192 NB.n74 NB.n73 19.7534
R193 NB.n73 NB.n72 19.7534
R194 NB.n72 NB.n71 19.7534
R195 NB.n71 NB.n70 19.7534
R196 NB.n70 NB.n69 19.7534
R197 NB.n69 NB.n68 19.7534
R198 NB.n68 NB.n67 19.7534
R199 NB.n67 NB.n66 19.7534
R200 NB.n66 NB.n65 19.7534
R201 NB.n65 NB.n64 19.7534
R202 NB.n64 NB.n63 19.7534
R203 NB.n63 NB.n62 19.7534
R204 NB.n62 NB.n61 19.7534
R205 NB.n61 NB.n60 19.7534
R206 NB.n60 NB.n59 19.7534
R207 NB.n98 NB.n97 19.7534
R208 NB.n97 NB.n96 19.7534
R209 NB.n96 NB.n95 19.7534
R210 NB.n95 NB.n94 19.7534
R211 NB.n94 NB.n93 19.7534
R212 NB.n93 NB.n92 19.7534
R213 NB.n92 NB.n91 19.7534
R214 NB.n91 NB.n90 19.7534
R215 NB.n90 NB.n89 19.7534
R216 NB.n89 NB.n88 19.7534
R217 NB.n88 NB.n87 19.7534
R218 NB.n87 NB.n86 19.7534
R219 NB.n86 NB.n85 19.7534
R220 NB.n85 NB.n84 19.7534
R221 NB.n84 NB.n83 19.7534
R222 NB.n83 NB.n82 19.7534
R223 NB.n82 NB.n81 19.7534
R224 NB.n81 NB.n80 19.7534
R225 NB.n117 NB.n116 19.7534
R226 NB.n116 NB.n115 19.7534
R227 NB.n115 NB.n114 19.7534
R228 NB.n114 NB.n113 19.7534
R229 NB.n113 NB.n112 19.7534
R230 NB.n112 NB.n111 19.7534
R231 NB.n111 NB.n110 19.7534
R232 NB.n110 NB.n109 19.7534
R233 NB.n109 NB.n108 19.7534
R234 NB.n108 NB.n107 19.7534
R235 NB.n107 NB.n106 19.7534
R236 NB.n106 NB.n105 19.7534
R237 NB.n105 NB.n104 19.7534
R238 NB.n104 NB.n103 19.7534
R239 NB.n103 NB.n102 19.7534
R240 NB.n102 NB.n101 19.7534
R241 NB.n101 NB.n100 19.7534
R242 NB.n100 NB.n99 19.7534
R243 NB.n138 NB.n137 19.7534
R244 NB.n137 NB.n136 19.7534
R245 NB.n136 NB.n135 19.7534
R246 NB.n135 NB.n134 19.7534
R247 NB.n134 NB.n133 19.7534
R248 NB.n133 NB.n132 19.7534
R249 NB.n132 NB.n131 19.7534
R250 NB.n131 NB.n130 19.7534
R251 NB.n130 NB.n129 19.7534
R252 NB.n129 NB.n128 19.7534
R253 NB.n128 NB.n127 19.7534
R254 NB.n127 NB.n126 19.7534
R255 NB.n126 NB.n125 19.7534
R256 NB.n125 NB.n124 19.7534
R257 NB.n124 NB.n123 19.7534
R258 NB.n123 NB.n122 19.7534
R259 NB.n122 NB.n121 19.7534
R260 NB.n121 NB.n120 19.7534
R261 NB.n157 NB.n156 19.7534
R262 NB.n156 NB.n155 19.7534
R263 NB.n155 NB.n154 19.7534
R264 NB.n154 NB.n153 19.7534
R265 NB.n153 NB.n152 19.7534
R266 NB.n152 NB.n151 19.7534
R267 NB.n151 NB.n150 19.7534
R268 NB.n150 NB.n149 19.7534
R269 NB.n149 NB.n148 19.7534
R270 NB.n148 NB.n147 19.7534
R271 NB.n147 NB.n146 19.7534
R272 NB.n146 NB.n145 19.7534
R273 NB.n145 NB.n144 19.7534
R274 NB.n144 NB.n143 19.7534
R275 NB.n143 NB.n142 19.7534
R276 NB.n142 NB.n141 19.7534
R277 NB.n141 NB.n140 19.7534
R278 NB.n140 NB.n139 19.7534
R279 NB.n79 NB.n39 19.3381
R280 NB.n79 NB.n78 16.4221
R281 NB.n119 NB.n118 16.4221
R282 NB.n159 NB.n158 16.4221
R283 NB.n19 NB.t19 14.6005
R284 NB.n18 NB.t18 14.6005
R285 NB.n17 NB.t17 14.6005
R286 NB.n16 NB.t16 14.6005
R287 NB.n15 NB.t15 14.6005
R288 NB.n14 NB.t14 14.6005
R289 NB.n13 NB.t13 14.6005
R290 NB.n12 NB.t12 14.6005
R291 NB.n11 NB.t11 14.6005
R292 NB.n10 NB.t10 14.6005
R293 NB.n9 NB.t9 14.6005
R294 NB.n8 NB.t8 14.6005
R295 NB.n7 NB.t7 14.6005
R296 NB.n6 NB.t6 14.6005
R297 NB.n5 NB.t5 14.6005
R298 NB.n4 NB.t4 14.6005
R299 NB.n3 NB.t3 14.6005
R300 NB.n2 NB.t2 14.6005
R301 NB.n1 NB.t1 14.6005
R302 NB.n38 NB.t20 14.6005
R303 NB.n37 NB.t21 14.6005
R304 NB.n36 NB.t22 14.6005
R305 NB.n35 NB.t23 14.6005
R306 NB.n34 NB.t24 14.6005
R307 NB.n33 NB.t25 14.6005
R308 NB.n32 NB.t26 14.6005
R309 NB.n31 NB.t27 14.6005
R310 NB.n30 NB.t28 14.6005
R311 NB.n29 NB.t29 14.6005
R312 NB.n28 NB.t30 14.6005
R313 NB.n27 NB.t31 14.6005
R314 NB.n26 NB.t32 14.6005
R315 NB.n25 NB.t33 14.6005
R316 NB.n24 NB.t34 14.6005
R317 NB.n23 NB.t35 14.6005
R318 NB.n22 NB.t36 14.6005
R319 NB.n21 NB.t37 14.6005
R320 NB.n20 NB.t38 14.6005
R321 NB.n58 NB.t59 14.6005
R322 NB.n57 NB.t58 14.6005
R323 NB.n56 NB.t57 14.6005
R324 NB.n55 NB.t56 14.6005
R325 NB.n54 NB.t55 14.6005
R326 NB.n53 NB.t54 14.6005
R327 NB.n52 NB.t53 14.6005
R328 NB.n51 NB.t52 14.6005
R329 NB.n50 NB.t51 14.6005
R330 NB.n49 NB.t50 14.6005
R331 NB.n48 NB.t49 14.6005
R332 NB.n47 NB.t48 14.6005
R333 NB.n46 NB.t47 14.6005
R334 NB.n45 NB.t46 14.6005
R335 NB.n44 NB.t45 14.6005
R336 NB.n43 NB.t44 14.6005
R337 NB.n42 NB.t43 14.6005
R338 NB.n41 NB.t42 14.6005
R339 NB.n40 NB.t41 14.6005
R340 NB.n77 NB.t60 14.6005
R341 NB.n76 NB.t61 14.6005
R342 NB.n75 NB.t62 14.6005
R343 NB.n74 NB.t63 14.6005
R344 NB.n73 NB.t64 14.6005
R345 NB.n72 NB.t65 14.6005
R346 NB.n71 NB.t66 14.6005
R347 NB.n70 NB.t67 14.6005
R348 NB.n69 NB.t68 14.6005
R349 NB.n68 NB.t69 14.6005
R350 NB.n67 NB.t70 14.6005
R351 NB.n66 NB.t71 14.6005
R352 NB.n65 NB.t72 14.6005
R353 NB.n64 NB.t73 14.6005
R354 NB.n63 NB.t74 14.6005
R355 NB.n62 NB.t75 14.6005
R356 NB.n61 NB.t76 14.6005
R357 NB.n60 NB.t77 14.6005
R358 NB.n59 NB.t78 14.6005
R359 NB.n98 NB.t99 14.6005
R360 NB.n97 NB.t98 14.6005
R361 NB.n96 NB.t97 14.6005
R362 NB.n95 NB.t96 14.6005
R363 NB.n94 NB.t95 14.6005
R364 NB.n93 NB.t94 14.6005
R365 NB.n92 NB.t93 14.6005
R366 NB.n91 NB.t92 14.6005
R367 NB.n90 NB.t91 14.6005
R368 NB.n89 NB.t90 14.6005
R369 NB.n88 NB.t89 14.6005
R370 NB.n87 NB.t88 14.6005
R371 NB.n86 NB.t87 14.6005
R372 NB.n85 NB.t86 14.6005
R373 NB.n84 NB.t85 14.6005
R374 NB.n83 NB.t84 14.6005
R375 NB.n82 NB.t83 14.6005
R376 NB.n81 NB.t82 14.6005
R377 NB.n80 NB.t81 14.6005
R378 NB.n117 NB.t100 14.6005
R379 NB.n116 NB.t101 14.6005
R380 NB.n115 NB.t102 14.6005
R381 NB.n114 NB.t103 14.6005
R382 NB.n113 NB.t104 14.6005
R383 NB.n112 NB.t105 14.6005
R384 NB.n111 NB.t106 14.6005
R385 NB.n110 NB.t107 14.6005
R386 NB.n109 NB.t108 14.6005
R387 NB.n108 NB.t109 14.6005
R388 NB.n107 NB.t110 14.6005
R389 NB.n106 NB.t111 14.6005
R390 NB.n105 NB.t112 14.6005
R391 NB.n104 NB.t113 14.6005
R392 NB.n103 NB.t114 14.6005
R393 NB.n102 NB.t115 14.6005
R394 NB.n101 NB.t116 14.6005
R395 NB.n100 NB.t117 14.6005
R396 NB.n99 NB.t118 14.6005
R397 NB.n138 NB.t139 14.6005
R398 NB.n137 NB.t138 14.6005
R399 NB.n136 NB.t137 14.6005
R400 NB.n135 NB.t136 14.6005
R401 NB.n134 NB.t135 14.6005
R402 NB.n133 NB.t134 14.6005
R403 NB.n132 NB.t133 14.6005
R404 NB.n131 NB.t132 14.6005
R405 NB.n130 NB.t131 14.6005
R406 NB.n129 NB.t130 14.6005
R407 NB.n128 NB.t129 14.6005
R408 NB.n127 NB.t128 14.6005
R409 NB.n126 NB.t127 14.6005
R410 NB.n125 NB.t126 14.6005
R411 NB.n124 NB.t125 14.6005
R412 NB.n123 NB.t124 14.6005
R413 NB.n122 NB.t123 14.6005
R414 NB.n121 NB.t122 14.6005
R415 NB.n120 NB.t121 14.6005
R416 NB.n157 NB.t140 14.6005
R417 NB.n156 NB.t141 14.6005
R418 NB.n155 NB.t142 14.6005
R419 NB.n154 NB.t143 14.6005
R420 NB.n153 NB.t144 14.6005
R421 NB.n152 NB.t145 14.6005
R422 NB.n151 NB.t146 14.6005
R423 NB.n150 NB.t147 14.6005
R424 NB.n149 NB.t148 14.6005
R425 NB.n148 NB.t149 14.6005
R426 NB.n147 NB.t150 14.6005
R427 NB.n146 NB.t151 14.6005
R428 NB.n145 NB.t152 14.6005
R429 NB.n144 NB.t153 14.6005
R430 NB.n143 NB.t154 14.6005
R431 NB.n142 NB.t155 14.6005
R432 NB.n141 NB.t156 14.6005
R433 NB.n140 NB.t157 14.6005
R434 NB.n139 NB.t158 14.6005
R435 NB.n39 NB.n19 10.7131
R436 NB.n39 NB.n38 10.7131
R437 NB.n78 NB.n58 9.87697
R438 NB.n78 NB.n77 9.87697
R439 NB.n118 NB.n98 9.87697
R440 NB.n118 NB.n117 9.87697
R441 NB.n158 NB.n138 9.87697
R442 NB.n158 NB.n157 9.87697
R443 NB.n159 NB.n119 2.9165
R444 NB.n119 NB.n79 2.9165
R445 VTN.n62 VTN.n61 104.197
R446 VTN.n62 VTN.n30 39.8345
R447 VTN.n0 VTN.t32 36.0256
R448 VTN.n15 VTN.t63 36.0256
R449 VTN.n31 VTN.t0 36.0256
R450 VTN.n46 VTN.t31 36.0256
R451 VTN.n14 VTN.n13 21.4256
R452 VTN.n13 VTN.n12 21.4256
R453 VTN.n12 VTN.n11 21.4256
R454 VTN.n11 VTN.n10 21.4256
R455 VTN.n10 VTN.n9 21.4256
R456 VTN.n9 VTN.n8 21.4256
R457 VTN.n8 VTN.n7 21.4256
R458 VTN.n7 VTN.n6 21.4256
R459 VTN.n6 VTN.n5 21.4256
R460 VTN.n5 VTN.n4 21.4256
R461 VTN.n4 VTN.n3 21.4256
R462 VTN.n3 VTN.n2 21.4256
R463 VTN.n2 VTN.n1 21.4256
R464 VTN.n1 VTN.n0 21.4256
R465 VTN.n29 VTN.n28 21.4256
R466 VTN.n28 VTN.n27 21.4256
R467 VTN.n27 VTN.n26 21.4256
R468 VTN.n26 VTN.n25 21.4256
R469 VTN.n25 VTN.n24 21.4256
R470 VTN.n24 VTN.n23 21.4256
R471 VTN.n23 VTN.n22 21.4256
R472 VTN.n22 VTN.n21 21.4256
R473 VTN.n21 VTN.n20 21.4256
R474 VTN.n20 VTN.n19 21.4256
R475 VTN.n19 VTN.n18 21.4256
R476 VTN.n18 VTN.n17 21.4256
R477 VTN.n17 VTN.n16 21.4256
R478 VTN.n16 VTN.n15 21.4256
R479 VTN.n45 VTN.n44 21.4256
R480 VTN.n44 VTN.n43 21.4256
R481 VTN.n43 VTN.n42 21.4256
R482 VTN.n42 VTN.n41 21.4256
R483 VTN.n41 VTN.n40 21.4256
R484 VTN.n40 VTN.n39 21.4256
R485 VTN.n39 VTN.n38 21.4256
R486 VTN.n38 VTN.n37 21.4256
R487 VTN.n37 VTN.n36 21.4256
R488 VTN.n36 VTN.n35 21.4256
R489 VTN.n35 VTN.n34 21.4256
R490 VTN.n34 VTN.n33 21.4256
R491 VTN.n33 VTN.n32 21.4256
R492 VTN.n32 VTN.n31 21.4256
R493 VTN.n60 VTN.n59 21.4256
R494 VTN.n59 VTN.n58 21.4256
R495 VTN.n58 VTN.n57 21.4256
R496 VTN.n57 VTN.n56 21.4256
R497 VTN.n56 VTN.n55 21.4256
R498 VTN.n55 VTN.n54 21.4256
R499 VTN.n54 VTN.n53 21.4256
R500 VTN.n53 VTN.n52 21.4256
R501 VTN.n52 VTN.n51 21.4256
R502 VTN.n51 VTN.n50 21.4256
R503 VTN.n50 VTN.n49 21.4256
R504 VTN.n49 VTN.n48 21.4256
R505 VTN.n48 VTN.n47 21.4256
R506 VTN.n47 VTN.n46 21.4256
R507 VTN.n14 VTN.t47 14.6005
R508 VTN.n13 VTN.t46 14.6005
R509 VTN.n12 VTN.t45 14.6005
R510 VTN.n11 VTN.t44 14.6005
R511 VTN.n10 VTN.t43 14.6005
R512 VTN.n9 VTN.t42 14.6005
R513 VTN.n8 VTN.t41 14.6005
R514 VTN.n7 VTN.t40 14.6005
R515 VTN.n6 VTN.t39 14.6005
R516 VTN.n5 VTN.t38 14.6005
R517 VTN.n4 VTN.t37 14.6005
R518 VTN.n3 VTN.t36 14.6005
R519 VTN.n2 VTN.t35 14.6005
R520 VTN.n1 VTN.t34 14.6005
R521 VTN.n0 VTN.t33 14.6005
R522 VTN.n29 VTN.t48 14.6005
R523 VTN.n28 VTN.t49 14.6005
R524 VTN.n27 VTN.t50 14.6005
R525 VTN.n26 VTN.t51 14.6005
R526 VTN.n25 VTN.t52 14.6005
R527 VTN.n24 VTN.t53 14.6005
R528 VTN.n23 VTN.t54 14.6005
R529 VTN.n22 VTN.t55 14.6005
R530 VTN.n21 VTN.t56 14.6005
R531 VTN.n20 VTN.t57 14.6005
R532 VTN.n19 VTN.t58 14.6005
R533 VTN.n18 VTN.t59 14.6005
R534 VTN.n17 VTN.t60 14.6005
R535 VTN.n16 VTN.t61 14.6005
R536 VTN.n15 VTN.t62 14.6005
R537 VTN.n45 VTN.t15 14.6005
R538 VTN.n44 VTN.t14 14.6005
R539 VTN.n43 VTN.t13 14.6005
R540 VTN.n42 VTN.t12 14.6005
R541 VTN.n41 VTN.t11 14.6005
R542 VTN.n40 VTN.t10 14.6005
R543 VTN.n39 VTN.t9 14.6005
R544 VTN.n38 VTN.t8 14.6005
R545 VTN.n37 VTN.t7 14.6005
R546 VTN.n36 VTN.t6 14.6005
R547 VTN.n35 VTN.t5 14.6005
R548 VTN.n34 VTN.t4 14.6005
R549 VTN.n33 VTN.t3 14.6005
R550 VTN.n32 VTN.t2 14.6005
R551 VTN.n31 VTN.t1 14.6005
R552 VTN.n60 VTN.t16 14.6005
R553 VTN.n59 VTN.t17 14.6005
R554 VTN.n58 VTN.t18 14.6005
R555 VTN.n57 VTN.t19 14.6005
R556 VTN.n56 VTN.t20 14.6005
R557 VTN.n55 VTN.t21 14.6005
R558 VTN.n54 VTN.t22 14.6005
R559 VTN.n53 VTN.t23 14.6005
R560 VTN.n52 VTN.t24 14.6005
R561 VTN.n51 VTN.t25 14.6005
R562 VTN.n50 VTN.t26 14.6005
R563 VTN.n49 VTN.t27 14.6005
R564 VTN.n48 VTN.t28 14.6005
R565 VTN.n47 VTN.t29 14.6005
R566 VTN.n46 VTN.t30 14.6005
R567 VTN VTN.n62 14.1305
R568 VTN.n30 VTN.n14 10.7131
R569 VTN.n30 VTN.n29 10.7131
R570 VTN.n61 VTN.n45 10.7131
R571 VTN.n61 VTN.n60 10.7131
R572 a_3107_2049.t4 a_3107_2049.t3 128.418
R573 a_3107_2049.t0 a_3107_2049.t2 13.8491
R574 a_3107_2049.t5 a_3107_2049.t4 9.9125
R575 a_3107_2049.t1 a_3107_2049.t5 9.9125
R576 a_3107_2049.t2 a_3107_2049.t1 8.4425
R577 a_17789_5800.n0 a_17789_5800.t2 80.1429
R578 a_17789_5800.t4 a_17789_5800.n0 74.7245
R579 a_17789_5800.n0 a_17789_5800.t3 66.1269
R580 a_17789_5800.t1 a_17789_5800.t5 13.9925
R581 a_17789_5800.t0 a_17789_5800.t1 6.57706
R582 a_17789_5800.t5 a_17789_5800.t4 5.0165
R583 a_6869_5800.t4 a_6869_5800.n0 80.8145
R584 a_6869_5800.n0 a_6869_5800.t2 80.5149
R585 a_6869_5800.n0 a_6869_5800.t3 66.1269
R586 a_6869_5800.t1 a_6869_5800.t5 14.2025
R587 a_6869_5800.t0 a_6869_5800.t1 6.57706
R588 a_6869_5800.t5 a_6869_5800.t4 5.0165
R589 a_1427_6669.n0 a_1427_6669.t5 85.3005
R590 a_1427_6669.n1 a_1427_6669.n0 81.1685
R591 a_1427_6669.n0 a_1427_6669.t4 81.0555
R592 a_1427_6669.n1 a_1427_6669.t3 71.4429
R593 a_1427_6669.t1 a_1427_6669.t2 28.8125
R594 a_1427_6669.t0 a_1427_6669.t1 8.53306
R595 a_1427_6669.t2 a_1427_6669.n1 5.0165
R596 a_14145_5800.t4 a_14145_5800.n0 80.7725
R597 a_14145_5800.n0 a_14145_5800.t3 23.8046
R598 a_14145_5800.n0 a_14145_5800.t1 12.3086
R599 a_14145_5800.t2 a_14145_5800.t4 6.1565
R600 a_14145_5800.t0 a_14145_5800.t2 3.55136
R601 a_10785_5800.n8 a_10785_5800.n7 78.6485
R602 a_10785_5800.n0 a_10785_5800.t4 58.4912
R603 a_10785_5800.n3 a_10785_5800.t11 58.4912
R604 a_10785_5800.n2 a_10785_5800.t7 50.905
R605 a_10785_5800.n1 a_10785_5800.t6 50.905
R606 a_10785_5800.n0 a_10785_5800.t5 50.905
R607 a_10785_5800.n5 a_10785_5800.t8 50.905
R608 a_10785_5800.n4 a_10785_5800.t9 50.905
R609 a_10785_5800.n3 a_10785_5800.t10 50.905
R610 a_10785_5800.n1 a_10785_5800.n0 38.7907
R611 a_10785_5800.n4 a_10785_5800.n3 38.7907
R612 a_10785_5800.n6 a_10785_5800.n5 34.9976
R613 a_10785_5800.n6 a_10785_5800.n2 34.9976
R614 a_10785_5800.t2 a_10785_5800.n8 26.4725
R615 a_10785_5800.n7 a_10785_5800.t3 24.2246
R616 a_10785_5800.n7 a_10785_5800.t0 12.7286
R617 a_10785_5800.n8 a_10785_5800.n6 8.88145
R618 a_10785_5800.n2 a_10785_5800.n1 7.58677
R619 a_10785_5800.n5 a_10785_5800.n4 7.58677
R620 a_10785_5800.t1 a_10785_5800.t2 3.55136
R621 a_11985_10449.t0 a_11985_10449.n6 66.46
R622 a_11985_10449.n0 a_11985_10449.t3 57.0573
R623 a_11985_10449.n3 a_11985_10449.t10 57.0573
R624 a_11985_10449.n2 a_11985_10449.t6 49.471
R625 a_11985_10449.n1 a_11985_10449.t5 49.471
R626 a_11985_10449.n0 a_11985_10449.t4 49.471
R627 a_11985_10449.n5 a_11985_10449.t7 49.471
R628 a_11985_10449.n4 a_11985_10449.t8 49.471
R629 a_11985_10449.n3 a_11985_10449.t9 49.471
R630 a_11985_10449.n1 a_11985_10449.n0 38.7907
R631 a_11985_10449.n4 a_11985_10449.n3 38.7907
R632 a_11985_10449.t2 a_11985_10449.t0 25.8725
R633 a_11985_10449.t1 a_11985_10449.t2 19.9319
R634 a_11985_10449.n2 a_11985_10449.n1 7.58677
R635 a_11985_10449.n5 a_11985_10449.n4 7.58677
R636 a_11985_10449.n6 a_11985_10449.n5 3.79364
R637 a_11985_10449.n6 a_11985_10449.n2 3.79364
R638 a_11549_11989.t1 a_11549_11989.n6 69.6564
R639 a_11549_11989.n0 a_11549_11989.t3 58.4912
R640 a_11549_11989.n3 a_11549_11989.t10 58.4912
R641 a_11549_11989.n2 a_11549_11989.t6 50.905
R642 a_11549_11989.n1 a_11549_11989.t5 50.905
R643 a_11549_11989.n0 a_11549_11989.t4 50.905
R644 a_11549_11989.n5 a_11549_11989.t7 50.905
R645 a_11549_11989.n4 a_11549_11989.t8 50.905
R646 a_11549_11989.n3 a_11549_11989.t9 50.905
R647 a_11549_11989.n1 a_11549_11989.n0 38.7907
R648 a_11549_11989.n4 a_11549_11989.n3 38.7907
R649 a_11549_11989.n6 a_11549_11989.n5 34.9976
R650 a_11549_11989.n6 a_11549_11989.n2 34.9976
R651 a_11549_11989.t2 a_11549_11989.t1 32.0525
R652 a_11549_11989.t0 a_11549_11989.t2 20.3039
R653 a_11549_11989.n2 a_11549_11989.n1 7.58677
R654 a_11549_11989.n5 a_11549_11989.n4 7.58677
R655 a_1469_11989.t4 a_1469_11989.t0 75.9425
R656 a_1469_11989.t0 a_1469_11989.t3 24.0146
R657 a_1469_11989.t2 a_1469_11989.t4 6.3665
R658 a_1469_11989.t1 a_1469_11989.t2 4.98594
R659 a_2037_10659.n2 a_2037_10659.t5 57.0573
R660 a_2037_10659.n3 a_2037_10659.t0 57.0573
R661 a_2037_10659.n1 a_2037_10659.n7 54.2465
R662 a_2037_10659.n2 a_2037_10659.t3 49.471
R663 a_2037_10659.n3 a_2037_10659.t2 49.471
R664 a_2037_10659.n0 a_2037_10659.n9 43.2965
R665 a_2037_10659.n9 a_2037_10659.t17 38.2557
R666 a_2037_10659.n9 a_2037_10659.t19 27.1543
R667 a_2037_10659.n1 a_2037_10659.n10 21.4865
R668 a_2037_10659.n7 a_2037_10659.n6 21.417
R669 a_2037_10659.t16 a_2037_10659.n1 16.7465
R670 a_2037_10659.n1 a_2037_10659.t14 13.8422
R671 a_2037_10659.n10 a_2037_10659.n0 12.4565
R672 a_2037_10659.n7 a_2037_10659.t6 12.4543
R673 a_2037_10659.n6 a_2037_10659.n5 10.4465
R674 a_2037_10659.n10 a_2037_10659.t9 9.36619
R675 a_2037_10659.n9 a_2037_10659.n8 4.64777
R676 a_2037_10659.n4 a_2037_10659.n3 3.79364
R677 a_2037_10659.n4 a_2037_10659.n2 3.79364
R678 a_2037_10659.t15 a_2037_10659.t16 3.72751
R679 a_2037_10659.n0 a_2037_10659.t12 3.67139
R680 a_2037_10659.n0 a_2037_10659.t13 3.19327
R681 a_2037_10659.n8 a_2037_10659.t7 3.17157
R682 a_2037_10659.n5 a_2037_10659.t4 3.16755
R683 a_2037_10659.n0 a_2037_10659.t10 3.00041
R684 a_2037_10659.n5 a_2037_10659.t1 3.00041
R685 a_2037_10659.n0 a_2037_10659.t11 2.99639
R686 a_2037_10659.n8 a_2037_10659.t8 2.99639
R687 a_2037_10659.n6 a_2037_10659.n4 1.88967
R688 a_1601_10659.n2 a_1601_10659.t7 58.4912
R689 a_1601_10659.n3 a_1601_10659.t2 58.4912
R690 a_1601_10659.n2 a_1601_10659.t5 50.905
R691 a_1601_10659.n3 a_1601_10659.t4 50.905
R692 a_1601_10659.n12 a_1601_10659.n8 50.2325
R693 a_1601_10659.n1 a_1601_10659.n9 42.6425
R694 a_1601_10659.n1 a_1601_10659.t18 37.6426
R695 a_1601_10659.n4 a_1601_10659.n3 34.9976
R696 a_1601_10659.n4 a_1601_10659.n2 34.9976
R697 a_1601_10659.t16 a_1601_10659.n12 21.4325
R698 a_1601_10659.n7 a_1601_10659.n6 20.8565
R699 a_1601_10659.n7 a_1601_10659.t17 20.0803
R700 a_1601_10659.n11 a_1601_10659.n10 19.5725
R701 a_1601_10659.n8 a_1601_10659.t8 17.1643
R702 a_1601_10659.n11 a_1601_10659.t14 13.2362
R703 a_1601_10659.n12 a_1601_10659.n11 9.3065
R704 a_1601_10659.n10 a_1601_10659.t9 9.07219
R705 a_1601_10659.n10 a_1601_10659.n1 7.5365
R706 a_1601_10659.n6 a_1601_10659.n4 7.20588
R707 a_1601_10659.n8 a_1601_10659.n7 7.1165
R708 a_1601_10659.n1 a_1601_10659.n0 4.6865
R709 a_1601_10659.n6 a_1601_10659.n5 4.5005
R710 a_1601_10659.t15 a_1601_10659.t16 3.87604
R711 a_1601_10659.n0 a_1601_10659.t11 3.52956
R712 a_1601_10659.n9 a_1601_10659.t0 3.23706
R713 a_1601_10659.n5 a_1601_10659.t6 3.23546
R714 a_1601_10659.n0 a_1601_10659.t13 3.07073
R715 a_1601_10659.n0 a_1601_10659.t10 2.78706
R716 a_1601_10659.n5 a_1601_10659.t3 2.73081
R717 a_1601_10659.n9 a_1601_10659.t1 2.72921
R718 a_1601_10659.n0 a_1601_10659.t12 2.72037
R719 a_3225_5800.t2 a_3225_5800.n4 92.1785
R720 a_3225_5800.n0 a_3225_5800.t4 57.0573
R721 a_3225_5800.n1 a_3225_5800.t7 57.0573
R722 a_3225_5800.n0 a_3225_5800.t5 49.471
R723 a_3225_5800.n1 a_3225_5800.t6 49.471
R724 a_3225_5800.n3 a_3225_5800.n2 40.3822
R725 a_3225_5800.n3 a_3225_5800.t3 16.4126
R726 a_3225_5800.n4 a_3225_5800.t1 12.3326
R727 a_3225_5800.n4 a_3225_5800.n3 7.4165
R728 a_3225_5800.n2 a_3225_5800.n1 3.79364
R729 a_3225_5800.n2 a_3225_5800.n0 3.79364
R730 a_3225_5800.t0 a_3225_5800.t2 3.72594
R731 a_1545_5800.t0 a_1545_5800.n5 94.4699
R732 a_1545_5800.n0 a_1545_5800.t4 58.4912
R733 a_1545_5800.n1 a_1545_5800.t7 58.4912
R734 a_1545_5800.n0 a_1545_5800.t5 50.905
R735 a_1545_5800.n1 a_1545_5800.t6 50.905
R736 a_1545_5800.n2 a_1545_5800.n1 34.9976
R737 a_1545_5800.n2 a_1545_5800.n0 34.9976
R738 a_1545_5800.n4 a_1545_5800.n3 30.4925
R739 a_1545_5800.n3 a_1545_5800.t3 21.0779
R740 a_1545_5800.n3 a_1545_5800.n2 20.7801
R741 a_1545_5800.n5 a_1545_5800.t1 12.7286
R742 a_1545_5800.n5 a_1545_5800.n4 12.3125
R743 a_1545_5800.n4 a_1545_5800.t2 11.9126
R744 a_2037_15740.n2 a_2037_15740.n1 48.2225
R745 a_2037_15740.n3 a_2037_15740.n2 37.2125
R746 a_2037_15740.n2 a_2037_15740.t2 17.2137
R747 a_2037_15740.t6 a_2037_15740.t0 11.6165
R748 a_2037_15740.n0 a_2037_15740.t4 7.34269
R749 a_2037_15740.t0 a_2037_15740.n3 7.0865
R750 a_2037_15740.n0 a_2037_15740.t5 5.90055
R751 a_2037_15740.n3 a_2037_15740.n0 5.4755
R752 a_2037_15740.n0 a_2037_15740.t1 5.00698
R753 a_2037_15740.t7 a_2037_15740.t6 4.5005
R754 a_2037_15740.n1 a_2037_15740.t12 3.5234
R755 a_2037_15740.n1 a_2037_15740.t14 3.40849
R756 a_2037_15740.t9 a_2037_15740.t7 3.16755
R757 a_2037_15740.n1 a_2037_15740.t13 3.1634
R758 a_2037_15740.n1 a_2037_15740.t11 3.14813
R759 a_1601_15740.n3 a_1601_15740.n2 55.2725
R760 a_1601_15740.n2 a_1601_15740.n1 31.6325
R761 a_1601_15740.n2 a_1601_15740.t3 16.3737
R762 a_1601_15740.t6 a_1601_15740.t2 10.5665
R763 a_1601_15740.n0 a_1601_15740.t1 8.55089
R764 a_1601_15740.t2 a_1601_15740.n3 7.0865
R765 a_1601_15740.n0 a_1601_15740.t5 6.4916
R766 a_1601_15740.t7 a_1601_15740.t6 5.7365
R767 a_1601_15740.n0 a_1601_15740.t0 5.28089
R768 a_1601_15740.n3 a_1601_15740.n0 5.15836
R769 a_1601_15740.n1 a_1601_15740.t11 3.55943
R770 a_1601_15740.n1 a_1601_15740.t14 3.25809
R771 a_1601_15740.t9 a_1601_15740.t7 3.23546
R772 a_1601_15740.n1 a_1601_15740.t13 3.08693
R773 a_1601_15740.n1 a_1601_15740.t12 2.99774
R774 a_43680_10659.t0 a_43680_10659.n14 41.5685
R775 a_43680_10659.n7 a_43680_10659.t13 10.8255
R776 a_43680_10659.n3 a_43680_10659.t9 10.8255
R777 a_43680_10659.n0 a_43680_10659.t5 10.8255
R778 a_43680_10659.n11 a_43680_10659.t17 10.7688
R779 a_43680_10659.n6 a_43680_10659.n2 7.4165
R780 a_43680_10659.n9 a_43680_10659.t10 5.58623
R781 a_43680_10659.n5 a_43680_10659.t6 5.58623
R782 a_43680_10659.n2 a_43680_10659.t2 5.58623
R783 a_43680_10659.n13 a_43680_10659.t14 5.52949
R784 a_43680_10659.n8 a_43680_10659.t11 5.40409
R785 a_43680_10659.n7 a_43680_10659.t12 5.40409
R786 a_43680_10659.n4 a_43680_10659.t7 5.40409
R787 a_43680_10659.n3 a_43680_10659.t8 5.40409
R788 a_43680_10659.n1 a_43680_10659.t3 5.40409
R789 a_43680_10659.n0 a_43680_10659.t4 5.40409
R790 a_43680_10659.n12 a_43680_10659.t15 5.34735
R791 a_43680_10659.n11 a_43680_10659.t16 5.34735
R792 a_43680_10659.n2 a_43680_10659.n1 5.23979
R793 a_43680_10659.n5 a_43680_10659.n4 5.23979
R794 a_43680_10659.n9 a_43680_10659.n8 5.23979
R795 a_43680_10659.n13 a_43680_10659.n12 5.23979
R796 a_43680_10659.n14 a_43680_10659.n13 4.5005
R797 a_43680_10659.n10 a_43680_10659.n9 4.5005
R798 a_43680_10659.n6 a_43680_10659.n5 4.5005
R799 a_43680_10659.t1 a_43680_10659.t0 3.91282
R800 a_43680_10659.n14 a_43680_10659.n10 2.9165
R801 a_43680_10659.n10 a_43680_10659.n6 2.9165
R802 a_43680_10659.n1 a_43680_10659.n0 1.08479
R803 a_43680_10659.n4 a_43680_10659.n3 1.08479
R804 a_43680_10659.n8 a_43680_10659.n7 1.08479
R805 a_43680_10659.n12 a_43680_10659.n11 1.08479
R806 a_39480_10659.n12 a_39480_10659.n0 45.9785
R807 a_39480_10659.n8 a_39480_10659.t11 10.5516
R808 a_39480_10659.n4 a_39480_10659.t7 10.5516
R809 a_39480_10659.n1 a_39480_10659.t3 10.5516
R810 a_39480_10659.t15 a_39480_10659.t14 10.4949
R811 a_39480_10659.n7 a_39480_10659.n3 7.4165
R812 a_39480_10659.t13 a_39480_10659.t12 5.3555
R813 a_39480_10659.n3 a_39480_10659.n2 5.3555
R814 a_39480_10659.n6 a_39480_10659.n5 5.3555
R815 a_39480_10659.n10 a_39480_10659.n9 5.3555
R816 a_39480_10659.n10 a_39480_10659.t8 5.1966
R817 a_39480_10659.n6 a_39480_10659.t4 5.1966
R818 a_39480_10659.n3 a_39480_10659.t0 5.1966
R819 a_39480_10659.n9 a_39480_10659.t9 5.13017
R820 a_39480_10659.n8 a_39480_10659.t10 5.13017
R821 a_39480_10659.n5 a_39480_10659.t5 5.13017
R822 a_39480_10659.n4 a_39480_10659.t6 5.13017
R823 a_39480_10659.n2 a_39480_10659.t1 5.13017
R824 a_39480_10659.n1 a_39480_10659.t2 5.13017
R825 a_39480_10659.t12 a_39480_10659.n12 4.5005
R826 a_39480_10659.n11 a_39480_10659.n10 4.5005
R827 a_39480_10659.n7 a_39480_10659.n6 4.5005
R828 a_39480_10659.n0 a_39480_10659.t22 4.40338
R829 a_39480_10659.n0 a_39480_10659.t16 3.9996
R830 a_39480_10659.n0 a_39480_10659.t23 3.91282
R831 a_39480_10659.n0 a_39480_10659.t17 3.53552
R832 a_39480_10659.n0 a_39480_10659.t18 3.53552
R833 a_39480_10659.n0 a_39480_10659.t19 3.53552
R834 a_39480_10659.n0 a_39480_10659.t24 3.53552
R835 a_39480_10659.n0 a_39480_10659.t20 3.53552
R836 a_39480_10659.n0 a_39480_10659.t21 3.53552
R837 a_39480_10659.t14 a_39480_10659.t13 3.25336
R838 a_39480_10659.n2 a_39480_10659.n1 3.25336
R839 a_39480_10659.n5 a_39480_10659.n4 3.25336
R840 a_39480_10659.n9 a_39480_10659.n8 3.25336
R841 a_39480_10659.n12 a_39480_10659.n11 2.9165
R842 a_39480_10659.n11 a_39480_10659.n7 2.9165
R843 a_35280_10659.t0 a_35280_10659.n14 50.5985
R844 a_35280_10659.n11 a_35280_10659.t17 10.3162
R845 a_35280_10659.n7 a_35280_10659.t13 10.3032
R846 a_35280_10659.n3 a_35280_10659.t9 10.3032
R847 a_35280_10659.n0 a_35280_10659.t5 10.3032
R848 a_35280_10659.n6 a_35280_10659.n2 7.4165
R849 a_35280_10659.n1 a_35280_10659.n0 5.42193
R850 a_35280_10659.n4 a_35280_10659.n3 5.42193
R851 a_35280_10659.n8 a_35280_10659.n7 5.42193
R852 a_35280_10659.n12 a_35280_10659.n11 5.42193
R853 a_35280_10659.n2 a_35280_10659.n1 5.32121
R854 a_35280_10659.n5 a_35280_10659.n4 5.32121
R855 a_35280_10659.n9 a_35280_10659.n8 5.32121
R856 a_35280_10659.n13 a_35280_10659.n12 5.32121
R857 a_35280_10659.n13 a_35280_10659.t14 4.99549
R858 a_35280_10659.n9 a_35280_10659.t10 4.98246
R859 a_35280_10659.n5 a_35280_10659.t6 4.98246
R860 a_35280_10659.n2 a_35280_10659.t2 4.98246
R861 a_35280_10659.n12 a_35280_10659.t15 4.89477
R862 a_35280_10659.n11 a_35280_10659.t16 4.89477
R863 a_35280_10659.n8 a_35280_10659.t11 4.88175
R864 a_35280_10659.n7 a_35280_10659.t12 4.88175
R865 a_35280_10659.n4 a_35280_10659.t7 4.88175
R866 a_35280_10659.n3 a_35280_10659.t8 4.88175
R867 a_35280_10659.n1 a_35280_10659.t3 4.88175
R868 a_35280_10659.n0 a_35280_10659.t4 4.88175
R869 a_35280_10659.n14 a_35280_10659.n13 4.5005
R870 a_35280_10659.n10 a_35280_10659.n9 4.5005
R871 a_35280_10659.n6 a_35280_10659.n5 4.5005
R872 a_35280_10659.t1 a_35280_10659.t0 3.62231
R873 a_35280_10659.n14 a_35280_10659.n10 2.9165
R874 a_35280_10659.n10 a_35280_10659.n6 2.9165
R875 a_31080_10659.n12 a_31080_10659.n0 55.2185
R876 a_31080_10659.t15 a_31080_10659.t14 10.5731
R877 a_31080_10659.n8 a_31080_10659.t11 10.5164
R878 a_31080_10659.n4 a_31080_10659.t7 10.5164
R879 a_31080_10659.n1 a_31080_10659.t3 10.5164
R880 a_31080_10659.t14 a_31080_10659.t13 7.5905
R881 a_31080_10659.n2 a_31080_10659.n1 7.5905
R882 a_31080_10659.n5 a_31080_10659.n4 7.5905
R883 a_31080_10659.n9 a_31080_10659.n8 7.5905
R884 a_31080_10659.n7 a_31080_10659.n3 7.4165
R885 a_31080_10659.t13 a_31080_10659.n13 5.28693
R886 a_31080_10659.n3 a_31080_10659.n2 5.28693
R887 a_31080_10659.n6 a_31080_10659.n5 5.28693
R888 a_31080_10659.n10 a_31080_10659.n9 5.28693
R889 a_31080_10659.n13 a_31080_10659.t12 5.28669
R890 a_31080_10659.n10 a_31080_10659.t8 5.22996
R891 a_31080_10659.n6 a_31080_10659.t4 5.22996
R892 a_31080_10659.n3 a_31080_10659.t0 5.22996
R893 a_31080_10659.n9 a_31080_10659.t9 5.09496
R894 a_31080_10659.n8 a_31080_10659.t10 5.09496
R895 a_31080_10659.n5 a_31080_10659.t5 5.09496
R896 a_31080_10659.n4 a_31080_10659.t6 5.09496
R897 a_31080_10659.n2 a_31080_10659.t1 5.09496
R898 a_31080_10659.n1 a_31080_10659.t2 5.09496
R899 a_31080_10659.n13 a_31080_10659.n12 4.5005
R900 a_31080_10659.n11 a_31080_10659.n10 4.5005
R901 a_31080_10659.n7 a_31080_10659.n6 4.5005
R902 a_31080_10659.n0 a_31080_10659.t22 4.40338
R903 a_31080_10659.n0 a_31080_10659.t24 3.9996
R904 a_31080_10659.n0 a_31080_10659.t23 3.91282
R905 a_31080_10659.n0 a_31080_10659.t16 3.53552
R906 a_31080_10659.n0 a_31080_10659.t17 3.53552
R907 a_31080_10659.n0 a_31080_10659.t18 3.53552
R908 a_31080_10659.n0 a_31080_10659.t19 3.53552
R909 a_31080_10659.n0 a_31080_10659.t20 3.53552
R910 a_31080_10659.n0 a_31080_10659.t21 3.53552
R911 a_31080_10659.n12 a_31080_10659.n11 2.9165
R912 a_31080_10659.n11 a_31080_10659.n7 2.9165
R913 a_26880_10659.n12 a_26880_10659.n0 60.2585
R914 a_26880_10659.t24 a_26880_10659.t23 10.847
R915 a_26880_10659.n8 a_26880_10659.t20 10.7903
R916 a_26880_10659.n4 a_26880_10659.t16 10.7903
R917 a_26880_10659.n1 a_26880_10659.t12 10.7903
R918 a_26880_10659.t23 a_26880_10659.t22 9.75907
R919 a_26880_10659.n2 a_26880_10659.n1 9.75907
R920 a_26880_10659.n5 a_26880_10659.n4 9.75907
R921 a_26880_10659.n9 a_26880_10659.n8 9.75907
R922 a_26880_10659.n7 a_26880_10659.n3 7.4165
R923 a_26880_10659.n13 a_26880_10659.t21 5.89489
R924 a_26880_10659.n10 a_26880_10659.t17 5.83815
R925 a_26880_10659.n6 a_26880_10659.t13 5.83815
R926 a_26880_10659.n3 a_26880_10659.t9 5.83815
R927 a_26880_10659.n9 a_26880_10659.t18 5.36887
R928 a_26880_10659.n8 a_26880_10659.t19 5.36887
R929 a_26880_10659.n5 a_26880_10659.t14 5.36887
R930 a_26880_10659.n4 a_26880_10659.t15 5.36887
R931 a_26880_10659.n2 a_26880_10659.t10 5.36887
R932 a_26880_10659.n1 a_26880_10659.t11 5.36887
R933 a_26880_10659.t22 a_26880_10659.n13 4.95264
R934 a_26880_10659.n3 a_26880_10659.n2 4.95264
R935 a_26880_10659.n6 a_26880_10659.n5 4.95264
R936 a_26880_10659.n10 a_26880_10659.n9 4.95264
R937 a_26880_10659.n13 a_26880_10659.n12 4.5005
R938 a_26880_10659.n11 a_26880_10659.n10 4.5005
R939 a_26880_10659.n7 a_26880_10659.n6 4.5005
R940 a_26880_10659.n0 a_26880_10659.t6 4.40338
R941 a_26880_10659.n0 a_26880_10659.t8 3.9996
R942 a_26880_10659.n0 a_26880_10659.t7 3.91282
R943 a_26880_10659.n0 a_26880_10659.t0 3.53552
R944 a_26880_10659.n0 a_26880_10659.t1 3.53552
R945 a_26880_10659.n0 a_26880_10659.t2 3.53552
R946 a_26880_10659.n0 a_26880_10659.t3 3.53552
R947 a_26880_10659.n0 a_26880_10659.t4 3.53552
R948 a_26880_10659.n0 a_26880_10659.t5 3.53552
R949 a_26880_10659.n12 a_26880_10659.n11 2.9165
R950 a_26880_10659.n11 a_26880_10659.n7 2.9165
R951 a_1400_1460.n81 a_1400_1460.n80 69.2345
R952 a_1400_1460.n54 a_1400_1460.t63 57.7091
R953 a_1400_1460.n65 a_1400_1460.t86 57.7091
R954 a_1400_1460.n31 a_1400_1460.t39 55.8189
R955 a_1400_1460.n42 a_1400_1460.t62 55.8189
R956 a_1400_1460.n82 a_1400_1460.t35 52.0258
R957 a_1400_1460.n82 a_1400_1460.t33 52.0258
R958 a_1400_1460.n64 a_1400_1460.t74 50.1228
R959 a_1400_1460.n63 a_1400_1460.t73 50.1228
R960 a_1400_1460.n62 a_1400_1460.t72 50.1228
R961 a_1400_1460.n61 a_1400_1460.t71 50.1228
R962 a_1400_1460.n60 a_1400_1460.t70 50.1228
R963 a_1400_1460.n59 a_1400_1460.t69 50.1228
R964 a_1400_1460.n58 a_1400_1460.t68 50.1228
R965 a_1400_1460.n57 a_1400_1460.t67 50.1228
R966 a_1400_1460.n56 a_1400_1460.t66 50.1228
R967 a_1400_1460.n55 a_1400_1460.t65 50.1228
R968 a_1400_1460.n54 a_1400_1460.t64 50.1228
R969 a_1400_1460.n75 a_1400_1460.t75 50.1228
R970 a_1400_1460.n74 a_1400_1460.t76 50.1228
R971 a_1400_1460.n73 a_1400_1460.t77 50.1228
R972 a_1400_1460.n72 a_1400_1460.t78 50.1228
R973 a_1400_1460.n71 a_1400_1460.t79 50.1228
R974 a_1400_1460.n70 a_1400_1460.t80 50.1228
R975 a_1400_1460.n69 a_1400_1460.t81 50.1228
R976 a_1400_1460.n68 a_1400_1460.t82 50.1228
R977 a_1400_1460.n67 a_1400_1460.t83 50.1228
R978 a_1400_1460.n66 a_1400_1460.t84 50.1228
R979 a_1400_1460.n65 a_1400_1460.t85 50.1228
R980 a_1400_1460.n41 a_1400_1460.t50 48.2326
R981 a_1400_1460.n40 a_1400_1460.t49 48.2326
R982 a_1400_1460.n39 a_1400_1460.t48 48.2326
R983 a_1400_1460.n38 a_1400_1460.t47 48.2326
R984 a_1400_1460.n37 a_1400_1460.t46 48.2326
R985 a_1400_1460.n36 a_1400_1460.t45 48.2326
R986 a_1400_1460.n35 a_1400_1460.t44 48.2326
R987 a_1400_1460.n34 a_1400_1460.t43 48.2326
R988 a_1400_1460.n33 a_1400_1460.t42 48.2326
R989 a_1400_1460.n32 a_1400_1460.t41 48.2326
R990 a_1400_1460.n31 a_1400_1460.t40 48.2326
R991 a_1400_1460.n52 a_1400_1460.t51 48.2326
R992 a_1400_1460.n51 a_1400_1460.t52 48.2326
R993 a_1400_1460.n50 a_1400_1460.t53 48.2326
R994 a_1400_1460.n49 a_1400_1460.t54 48.2326
R995 a_1400_1460.n48 a_1400_1460.t55 48.2326
R996 a_1400_1460.n47 a_1400_1460.t56 48.2326
R997 a_1400_1460.n46 a_1400_1460.t57 48.2326
R998 a_1400_1460.n45 a_1400_1460.t58 48.2326
R999 a_1400_1460.n44 a_1400_1460.t59 48.2326
R1000 a_1400_1460.n43 a_1400_1460.t60 48.2326
R1001 a_1400_1460.n42 a_1400_1460.t61 48.2326
R1002 a_1400_1460.n7 a_1400_1460.t26 25.1263
R1003 a_1400_1460.n81 a_1400_1460.t38 24.0451
R1004 a_1400_1460.n2 a_1400_1460.t8 22.5662
R1005 a_1400_1460.n83 a_1400_1460.n81 22.0925
R1006 a_1400_1460.n0 a_1400_1460.t18 21.5743
R1007 a_1400_1460.n25 a_1400_1460.t30 18.7666
R1008 a_1400_1460.n27 a_1400_1460.t6 18.7666
R1009 a_1400_1460.n29 a_1400_1460.t31 18.7666
R1010 a_1400_1460.n79 a_1400_1460.t21 18.7666
R1011 a_1400_1460.n24 a_1400_1460.t14 18.3895
R1012 a_1400_1460.n26 a_1400_1460.t13 18.3895
R1013 a_1400_1460.n28 a_1400_1460.t4 18.3895
R1014 a_1400_1460.n30 a_1400_1460.t5 18.3895
R1015 a_1400_1460.n22 a_1400_1460.t1 18.0662
R1016 a_1400_1460.n9 a_1400_1460.t11 17.1182
R1017 a_1400_1460.n16 a_1400_1460.t15 16.7443
R1018 a_1400_1460.n17 a_1400_1460.t16 16.7443
R1019 a_1400_1460.n18 a_1400_1460.t27 16.7443
R1020 a_1400_1460.n19 a_1400_1460.t28 16.7443
R1021 a_1400_1460.n0 a_1400_1460.t17 16.5583
R1022 a_1400_1460.n1 a_1400_1460.t20 16.5583
R1023 a_1400_1460.n5 a_1400_1460.t23 16.5583
R1024 a_1400_1460.n77 a_1400_1460.n76 14.5175
R1025 a_1400_1460.n29 a_1400_1460.n28 14.4665
R1026 a_1400_1460.n27 a_1400_1460.n26 14.4665
R1027 a_1400_1460.n25 a_1400_1460.n24 14.4665
R1028 a_1400_1460.n5 a_1400_1460.n4 14.3675
R1029 a_1400_1460.n23 a_1400_1460.n22 14.3225
R1030 a_1400_1460.n23 a_1400_1460.t29 13.8895
R1031 a_1400_1460.n78 a_1400_1460.t24 13.8895
R1032 a_1400_1460.n6 a_1400_1460.n5 13.5965
R1033 a_1400_1460.n10 a_1400_1460.t2 13.0502
R1034 a_1400_1460.n11 a_1400_1460.t3 13.0502
R1035 a_1400_1460.n12 a_1400_1460.t9 13.0502
R1036 a_1400_1460.n13 a_1400_1460.t10 13.0502
R1037 a_1400_1460.n14 a_1400_1460.t37 13.0502
R1038 a_1400_1460.n15 a_1400_1460.t36 13.0502
R1039 a_1400_1460.n20 a_1400_1460.n6 12.8735
R1040 a_1400_1460.n83 a_1400_1460.n82 12.6355
R1041 a_1400_1460.n7 a_1400_1460.t25 12.0583
R1042 a_1400_1460.n3 a_1400_1460.n2 11.6165
R1043 a_1400_1460.n4 a_1400_1460.n3 11.4965
R1044 a_1400_1460.n21 a_1400_1460.n20 11.4065
R1045 a_1400_1460.n14 a_1400_1460.n13 11.3165
R1046 a_1400_1460.n12 a_1400_1460.n11 11.3165
R1047 a_1400_1460.n10 a_1400_1460.n9 11.3165
R1048 a_1400_1460.n80 a_1400_1460.n30 9.8465
R1049 a_1400_1460.n78 a_1400_1460.n77 9.28124
R1050 a_1400_1460.n2 a_1400_1460.t7 8.55019
R1051 a_1400_1460.n8 a_1400_1460.t12 8.55019
R1052 a_1400_1460.n21 a_1400_1460.t0 8.55019
R1053 a_1400_1460.t34 a_1400_1460.t32 7.92944
R1054 a_1400_1460.n64 a_1400_1460.n63 7.58677
R1055 a_1400_1460.n63 a_1400_1460.n62 7.58677
R1056 a_1400_1460.n62 a_1400_1460.n61 7.58677
R1057 a_1400_1460.n61 a_1400_1460.n60 7.58677
R1058 a_1400_1460.n60 a_1400_1460.n59 7.58677
R1059 a_1400_1460.n59 a_1400_1460.n58 7.58677
R1060 a_1400_1460.n58 a_1400_1460.n57 7.58677
R1061 a_1400_1460.n57 a_1400_1460.n56 7.58677
R1062 a_1400_1460.n56 a_1400_1460.n55 7.58677
R1063 a_1400_1460.n55 a_1400_1460.n54 7.58677
R1064 a_1400_1460.n75 a_1400_1460.n74 7.58677
R1065 a_1400_1460.n74 a_1400_1460.n73 7.58677
R1066 a_1400_1460.n73 a_1400_1460.n72 7.58677
R1067 a_1400_1460.n72 a_1400_1460.n71 7.58677
R1068 a_1400_1460.n71 a_1400_1460.n70 7.58677
R1069 a_1400_1460.n70 a_1400_1460.n69 7.58677
R1070 a_1400_1460.n69 a_1400_1460.n68 7.58677
R1071 a_1400_1460.n68 a_1400_1460.n67 7.58677
R1072 a_1400_1460.n67 a_1400_1460.n66 7.58677
R1073 a_1400_1460.n66 a_1400_1460.n65 7.58677
R1074 a_1400_1460.n41 a_1400_1460.n40 7.58677
R1075 a_1400_1460.n40 a_1400_1460.n39 7.58677
R1076 a_1400_1460.n39 a_1400_1460.n38 7.58677
R1077 a_1400_1460.n38 a_1400_1460.n37 7.58677
R1078 a_1400_1460.n37 a_1400_1460.n36 7.58677
R1079 a_1400_1460.n36 a_1400_1460.n35 7.58677
R1080 a_1400_1460.n35 a_1400_1460.n34 7.58677
R1081 a_1400_1460.n34 a_1400_1460.n33 7.58677
R1082 a_1400_1460.n33 a_1400_1460.n32 7.58677
R1083 a_1400_1460.n32 a_1400_1460.n31 7.58677
R1084 a_1400_1460.n52 a_1400_1460.n51 7.58677
R1085 a_1400_1460.n51 a_1400_1460.n50 7.58677
R1086 a_1400_1460.n50 a_1400_1460.n49 7.58677
R1087 a_1400_1460.n49 a_1400_1460.n48 7.58677
R1088 a_1400_1460.n48 a_1400_1460.n47 7.58677
R1089 a_1400_1460.n47 a_1400_1460.n46 7.58677
R1090 a_1400_1460.n46 a_1400_1460.n45 7.58677
R1091 a_1400_1460.n45 a_1400_1460.n44 7.58677
R1092 a_1400_1460.n44 a_1400_1460.n43 7.58677
R1093 a_1400_1460.n43 a_1400_1460.n42 7.58677
R1094 a_1400_1460.n4 a_1400_1460.t19 7.1126
R1095 a_1400_1460.n6 a_1400_1460.t22 7.1126
R1096 a_1400_1460.n8 a_1400_1460.n7 6.6965
R1097 a_1400_1460.n79 a_1400_1460.n78 5.5265
R1098 a_1400_1460.t32 a_1400_1460.n83 5.2925
R1099 a_1400_1460.n24 a_1400_1460.n23 5.1065
R1100 a_1400_1460.n1 a_1400_1460.n0 5.0165
R1101 a_1400_1460.n19 a_1400_1460.n18 5.0165
R1102 a_1400_1460.n18 a_1400_1460.n17 5.0165
R1103 a_1400_1460.n17 a_1400_1460.n16 5.0165
R1104 a_1400_1460.n16 a_1400_1460.n15 5.0165
R1105 a_1400_1460.n15 a_1400_1460.n14 5.0165
R1106 a_1400_1460.n13 a_1400_1460.n12 5.0165
R1107 a_1400_1460.n11 a_1400_1460.n10 5.0165
R1108 a_1400_1460.n80 a_1400_1460.n79 4.5965
R1109 a_1400_1460.n22 a_1400_1460.n21 4.5005
R1110 a_1400_1460.n9 a_1400_1460.n8 4.5005
R1111 a_1400_1460.n76 a_1400_1460.n75 3.79364
R1112 a_1400_1460.n76 a_1400_1460.n64 3.79364
R1113 a_1400_1460.n53 a_1400_1460.n52 3.79364
R1114 a_1400_1460.n53 a_1400_1460.n41 3.79364
R1115 a_1400_1460.n77 a_1400_1460.n53 3.23148
R1116 a_1400_1460.n3 a_1400_1460.n1 2.0765
R1117 a_1400_1460.n20 a_1400_1460.n19 1.6565
R1118 a_1400_1460.n30 a_1400_1460.n29 1.0265
R1119 a_1400_1460.n28 a_1400_1460.n27 1.0265
R1120 a_1400_1460.n26 a_1400_1460.n25 1.0265
R1121 a_35349_62080.n7 a_35349_62080.t16 81.5056
R1122 a_35349_62080.n3 a_35349_62080.t20 32.9843
R1123 a_35349_62080.n0 a_35349_62080.t6 31.9628
R1124 a_35349_62080.n1 a_35349_62080.t1 31.9628
R1125 a_35349_62080.n11 a_35349_62080.t21 31.9628
R1126 a_35349_62080.n12 a_35349_62080.t24 31.9628
R1127 a_35349_62080.n5 a_35349_62080.n3 29.5085
R1128 a_35349_62080.n14 a_35349_62080.n10 19.6439
R1129 a_35349_62080.n4 a_35349_62080.t25 18.2198
R1130 a_35349_62080.n4 a_35349_62080.t26 18.2198
R1131 a_35349_62080.t7 a_35349_62080.n16 15.2765
R1132 a_35349_62080.n7 a_35349_62080.n6 14.3465
R1133 a_35349_62080.n2 a_35349_62080.n0 12.3316
R1134 a_35349_62080.n2 a_35349_62080.n1 12.3316
R1135 a_35349_62080.n13 a_35349_62080.n11 12.3316
R1136 a_35349_62080.n13 a_35349_62080.n12 12.3316
R1137 a_35349_62080.n5 a_35349_62080.n4 11.4304
R1138 a_35349_62080.n6 a_35349_62080.t0 11.3844
R1139 a_35349_62080.n6 a_35349_62080.n5 8.4665
R1140 a_35349_62080.n9 a_35349_62080.n7 8.0225
R1141 a_35349_62080.n16 a_35349_62080.n14 7.5365
R1142 a_35349_62080.n0 a_35349_62080.t4 7.3005
R1143 a_35349_62080.n1 a_35349_62080.t3 7.3005
R1144 a_35349_62080.n11 a_35349_62080.t22 7.3005
R1145 a_35349_62080.n12 a_35349_62080.t23 7.3005
R1146 a_35349_62080.n14 a_35349_62080.n13 5.70935
R1147 a_35349_62080.n3 a_35349_62080.t18 5.23231
R1148 a_35349_62080.n9 a_35349_62080.n8 5.1065
R1149 a_35349_62080.t8 a_35349_62080.t7 4.5005
R1150 a_35349_62080.n16 a_35349_62080.n15 4.5005
R1151 a_35349_62080.n10 a_35349_62080.n9 4.5005
R1152 a_35349_62080.n15 a_35349_62080.t15 3.4183
R1153 a_35349_62080.n8 a_35349_62080.t5 3.4183
R1154 a_35349_62080.t10 a_35349_62080.t8 3.4183
R1155 a_35349_62080.n15 a_35349_62080.t14 3.02615
R1156 a_35349_62080.n8 a_35349_62080.t2 3.02615
R1157 a_35349_62080.n10 a_35349_62080.n2 1.20935
R1158 a_34789_72329.n8 a_34789_72329.t7 106.569
R1159 a_34789_72329.n15 a_34789_72329.t24 32.1488
R1160 a_34789_72329.n1 a_34789_72329.t25 31.9628
R1161 a_34789_72329.n2 a_34789_72329.t28 31.9628
R1162 a_34789_72329.n4 a_34789_72329.t14 31.9628
R1163 a_34789_72329.n5 a_34789_72329.t9 31.9628
R1164 a_34789_72329.n19 a_34789_72329.t29 31.9628
R1165 a_34789_72329.n20 a_34789_72329.t32 31.9628
R1166 a_34789_72329.n23 a_34789_72329.t20 31.9628
R1167 a_34789_72329.n24 a_34789_72329.t15 31.9628
R1168 a_34789_72329.n7 a_34789_72329.t33 22.8101
R1169 a_34789_72329.n7 a_34789_72329.t34 22.8101
R1170 a_34789_72329.n16 a_34789_72329.t23 22.8101
R1171 a_34789_72329.n16 a_34789_72329.t21 22.8101
R1172 a_34789_72329.n11 a_34789_72329.n9 20.2025
R1173 a_34789_72329.n22 a_34789_72329.n18 19.9925
R1174 a_34789_72329.n17 a_34789_72329.n15 17.4965
R1175 a_34789_72329.n15 a_34789_72329.t1 16.6848
R1176 a_34789_72329.n14 a_34789_72329.n3 16.3287
R1177 a_34789_72329.n9 a_34789_72329.n8 12.9665
R1178 a_34789_72329.n3 a_34789_72329.n1 12.3316
R1179 a_34789_72329.n3 a_34789_72329.n2 12.3316
R1180 a_34789_72329.n6 a_34789_72329.n4 12.3316
R1181 a_34789_72329.n6 a_34789_72329.n5 12.3316
R1182 a_34789_72329.n21 a_34789_72329.n19 12.3316
R1183 a_34789_72329.n21 a_34789_72329.n20 12.3316
R1184 a_34789_72329.n25 a_34789_72329.n23 12.3316
R1185 a_34789_72329.n25 a_34789_72329.n24 12.3316
R1186 a_34789_72329.n14 a_34789_72329.n13 10.9865
R1187 a_34789_72329.n0 a_34789_72329.n25 10.8927
R1188 a_34789_72329.n13 a_34789_72329.n11 10.7765
R1189 a_34789_72329.n8 a_34789_72329.t0 10.5814
R1190 a_34789_72329.t5 a_34789_72329.n27 9.3965
R1191 a_34789_72329.n0 a_34789_72329.n26 9.3965
R1192 a_34789_72329.n11 a_34789_72329.n10 9.0005
R1193 a_34789_72329.n0 a_34789_72329.n22 8.2325
R1194 a_34789_72329.n9 a_34789_72329.n7 7.6422
R1195 a_34789_72329.n1 a_34789_72329.t26 7.3005
R1196 a_34789_72329.n2 a_34789_72329.t27 7.3005
R1197 a_34789_72329.n4 a_34789_72329.t12 7.3005
R1198 a_34789_72329.n5 a_34789_72329.t11 7.3005
R1199 a_34789_72329.n19 a_34789_72329.t30 7.3005
R1200 a_34789_72329.n20 a_34789_72329.t31 7.3005
R1201 a_34789_72329.n23 a_34789_72329.t18 7.3005
R1202 a_34789_72329.n24 a_34789_72329.t17 7.3005
R1203 a_34789_72329.n17 a_34789_72329.n16 6.99199
R1204 a_34789_72329.n27 a_34789_72329.n0 6.8825
R1205 a_34789_72329.n27 a_34789_72329.n14 6.4865
R1206 a_34789_72329.n22 a_34789_72329.n21 6.21145
R1207 a_34789_72329.n13 a_34789_72329.n6 6.14956
R1208 a_34789_72329.n18 a_34789_72329.t22 5.8954
R1209 a_34789_72329.n18 a_34789_72329.n17 5.3165
R1210 a_34789_72329.n13 a_34789_72329.n12 4.5005
R1211 a_34789_72329.n26 a_34789_72329.t19 3.4183
R1212 a_34789_72329.t6 a_34789_72329.t5 3.4183
R1213 a_34789_72329.n12 a_34789_72329.t13 3.36205
R1214 a_34789_72329.n10 a_34789_72329.t4 3.36205
R1215 a_34789_72329.n12 a_34789_72329.t10 3.0824
R1216 a_34789_72329.n10 a_34789_72329.t3 3.0824
R1217 a_34789_72329.n26 a_34789_72329.t16 3.02615
R1218 a_4409_62080.n6 a_4409_62080.t6 88.6288
R1219 a_4409_62080.n1 a_4409_62080.t15 31.9628
R1220 a_4409_62080.n2 a_4409_62080.t10 31.9628
R1221 a_4409_62080.n10 a_4409_62080.t21 31.9628
R1222 a_4409_62080.n11 a_4409_62080.t24 31.9628
R1223 a_4409_62080.n4 a_4409_62080.t20 27.1873
R1224 a_4409_62080.n0 a_4409_62080.n5 19.8964
R1225 a_4409_62080.n13 a_4409_62080.n9 19.6439
R1226 a_4409_62080.n5 a_4409_62080.t25 18.2198
R1227 a_4409_62080.n5 a_4409_62080.t26 18.2198
R1228 a_4409_62080.t1 a_4409_62080.n15 15.2765
R1229 a_4409_62080.n6 a_4409_62080.n0 13.9265
R1230 a_4409_62080.n3 a_4409_62080.n1 12.3316
R1231 a_4409_62080.n3 a_4409_62080.n2 12.3316
R1232 a_4409_62080.n12 a_4409_62080.n10 12.3316
R1233 a_4409_62080.n12 a_4409_62080.n11 12.3316
R1234 a_4409_62080.n0 a_4409_62080.n4 11.8025
R1235 a_4409_62080.n0 a_4409_62080.t0 11.3844
R1236 a_4409_62080.n8 a_4409_62080.n6 8.4425
R1237 a_4409_62080.n15 a_4409_62080.n13 7.5365
R1238 a_4409_62080.n1 a_4409_62080.t13 7.3005
R1239 a_4409_62080.n2 a_4409_62080.t12 7.3005
R1240 a_4409_62080.n10 a_4409_62080.t22 7.3005
R1241 a_4409_62080.n11 a_4409_62080.t23 7.3005
R1242 a_4409_62080.n13 a_4409_62080.n12 5.70935
R1243 a_4409_62080.n8 a_4409_62080.n7 5.1065
R1244 a_4409_62080.n4 a_4409_62080.t2 5.01012
R1245 a_4409_62080.t16 a_4409_62080.t1 4.5005
R1246 a_4409_62080.n15 a_4409_62080.n14 4.5005
R1247 a_4409_62080.n9 a_4409_62080.n8 4.5005
R1248 a_4409_62080.n14 a_4409_62080.t4 3.4183
R1249 a_4409_62080.n7 a_4409_62080.t14 3.4183
R1250 a_4409_62080.t18 a_4409_62080.t16 3.4183
R1251 a_4409_62080.n14 a_4409_62080.t5 3.02615
R1252 a_4409_62080.n7 a_4409_62080.t11 3.02615
R1253 a_4409_62080.n9 a_4409_62080.n3 1.20935
R1254 a_3849_72329.n7 a_3849_72329.t13 125.297
R1255 a_3849_72329.n0 a_3849_72329.t22 31.9628
R1256 a_3849_72329.n1 a_3849_72329.t25 31.9628
R1257 a_3849_72329.n3 a_3849_72329.t8 31.9628
R1258 a_3849_72329.n4 a_3849_72329.t3 31.9628
R1259 a_3849_72329.n10 a_3849_72329.t0 23.5474
R1260 a_3849_72329.n8 a_3849_72329.t26 22.8101
R1261 a_3849_72329.n8 a_3849_72329.t27 22.8101
R1262 a_3849_72329.n12 a_3849_72329.n10 20.2025
R1263 a_3849_72329.n6 a_3849_72329.t21 16.3989
R1264 a_3849_72329.n15 a_3849_72329.n2 16.3287
R1265 a_3849_72329.n2 a_3849_72329.n0 12.3316
R1266 a_3849_72329.n2 a_3849_72329.n1 12.3316
R1267 a_3849_72329.n5 a_3849_72329.n3 12.3316
R1268 a_3849_72329.n5 a_3849_72329.n4 12.3316
R1269 a_3849_72329.n6 a_3849_72329.t15 11.1661
R1270 a_3849_72329.n15 a_3849_72329.n14 10.9865
R1271 a_3849_72329.n14 a_3849_72329.n12 10.7765
R1272 a_3849_72329.n9 a_3849_72329.n7 9.54571
R1273 a_3849_72329.t9 a_3849_72329.t1 9.3965
R1274 a_3849_72329.n17 a_3849_72329.n16 9.3965
R1275 a_3849_72329.n12 a_3849_72329.n11 9.0005
R1276 a_3849_72329.n0 a_3849_72329.t23 7.3005
R1277 a_3849_72329.n1 a_3849_72329.t24 7.3005
R1278 a_3849_72329.n3 a_3849_72329.t6 7.3005
R1279 a_3849_72329.n4 a_3849_72329.t5 7.3005
R1280 a_3849_72329.n17 a_3849_72329.n15 6.4865
R1281 a_3849_72329.t1 a_3849_72329.n17 6.2765
R1282 a_3849_72329.n14 a_3849_72329.n5 6.14956
R1283 a_3849_72329.n10 a_3849_72329.n9 5.40887
R1284 a_3849_72329.n14 a_3849_72329.n13 4.5005
R1285 a_3849_72329.n16 a_3849_72329.t20 3.4183
R1286 a_3849_72329.t11 a_3849_72329.t9 3.4183
R1287 a_3849_72329.n13 a_3849_72329.t7 3.36205
R1288 a_3849_72329.n11 a_3849_72329.t18 3.36205
R1289 a_3849_72329.n13 a_3849_72329.t4 3.0824
R1290 a_3849_72329.n11 a_3849_72329.t17 3.0824
R1291 a_3849_72329.n16 a_3849_72329.t19 3.02615
R1292 a_3849_72329.n9 a_3849_72329.n8 2.23383
R1293 a_3849_72329.n7 a_3849_72329.n6 1.6565
R1294 a_34929_67569.n1 a_34929_67569.t19 31.9628
R1295 a_34929_67569.n2 a_34929_67569.t22 31.9628
R1296 a_34929_67569.n12 a_34929_67569.t10 31.9628
R1297 a_34929_67569.n13 a_34929_67569.t5 31.9628
R1298 a_34929_67569.n8 a_34929_67569.t18 24.3868
R1299 a_34929_67569.n5 a_34929_67569.t23 22.8101
R1300 a_34929_67569.n5 a_34929_67569.t24 22.8101
R1301 a_34929_67569.n7 a_34929_67569.n6 17.8625
R1302 a_34929_67569.t11 a_34929_67569.t1 15.2765
R1303 a_34929_67569.n4 a_34929_67569.t2 14.5344
R1304 a_34929_67569.n3 a_34929_67569.n1 12.3316
R1305 a_34929_67569.n3 a_34929_67569.n2 12.3316
R1306 a_34929_67569.n14 a_34929_67569.n12 12.3316
R1307 a_34929_67569.n14 a_34929_67569.n13 12.3316
R1308 a_34929_67569.n0 a_34929_67569.n14 10.8927
R1309 a_34929_67569.n0 a_34929_67569.n10 10.7765
R1310 a_34929_67569.n4 a_34929_67569.t16 10.2057
R1311 a_34929_67569.n0 a_34929_67569.n11 9.3965
R1312 a_34929_67569.n15 a_34929_67569.n0 9.0725
R1313 a_34929_67569.n8 a_34929_67569.n7 8.4665
R1314 a_34929_67569.t1 a_34929_67569.n15 7.3265
R1315 a_34929_67569.n1 a_34929_67569.t20 7.3005
R1316 a_34929_67569.n2 a_34929_67569.t21 7.3005
R1317 a_34929_67569.n12 a_34929_67569.t8 7.3005
R1318 a_34929_67569.n13 a_34929_67569.t7 7.3005
R1319 a_34929_67569.n6 a_34929_67569.n5 6.97304
R1320 a_34929_67569.n10 a_34929_67569.n8 6.9065
R1321 a_34929_67569.n6 a_34929_67569.n4 6.2765
R1322 a_34929_67569.n7 a_34929_67569.t4 6.06839
R1323 a_34929_67569.n15 a_34929_67569.n3 6.06587
R1324 a_34929_67569.n10 a_34929_67569.n9 4.8965
R1325 a_34929_67569.t12 a_34929_67569.t11 4.5005
R1326 a_34929_67569.n11 a_34929_67569.t9 3.4183
R1327 a_34929_67569.n9 a_34929_67569.t3 3.4183
R1328 a_34929_67569.t14 a_34929_67569.t12 3.4183
R1329 a_34929_67569.n11 a_34929_67569.t6 3.02615
R1330 a_34929_67569.n9 a_34929_67569.t0 3.02615
R1331 a_35349_66700.n2 a_35349_66700.t12 31.9628
R1332 a_35349_66700.n3 a_35349_66700.t7 31.9628
R1333 a_35349_66700.n18 a_35349_66700.t21 31.9628
R1334 a_35349_66700.n19 a_35349_66700.t24 31.9628
R1335 a_35349_66700.n5 a_35349_66700.t18 31.9628
R1336 a_35349_66700.n6 a_35349_66700.t13 31.9628
R1337 a_35349_66700.n14 a_35349_66700.t25 31.9628
R1338 a_35349_66700.n15 a_35349_66700.t28 31.9628
R1339 a_35349_66700.n0 a_35349_66700.t1 28.4217
R1340 a_35349_66700.t5 a_35349_66700.n24 22.8785
R1341 a_35349_66700.n0 a_35349_66700.t20 18.5068
R1342 a_35349_66700.n10 a_35349_66700.t29 18.2198
R1343 a_35349_66700.n10 a_35349_66700.t30 18.2198
R1344 a_35349_66700.n21 a_35349_66700.n17 16.0025
R1345 a_35349_66700.n23 a_35349_66700.n1 15.2765
R1346 a_35349_66700.n11 a_35349_66700.n0 13.2725
R1347 a_35349_66700.n21 a_35349_66700.n20 12.4827
R1348 a_35349_66700.n4 a_35349_66700.n2 12.3316
R1349 a_35349_66700.n4 a_35349_66700.n3 12.3316
R1350 a_35349_66700.n20 a_35349_66700.n18 12.3316
R1351 a_35349_66700.n20 a_35349_66700.n19 12.3316
R1352 a_35349_66700.n7 a_35349_66700.n5 12.3316
R1353 a_35349_66700.n7 a_35349_66700.n6 12.3316
R1354 a_35349_66700.n16 a_35349_66700.n14 12.3316
R1355 a_35349_66700.n16 a_35349_66700.n15 12.3316
R1356 a_35349_66700.n11 a_35349_66700.n10 11.5548
R1357 a_35349_66700.n0 a_35349_66700.t0 11.3974
R1358 a_35349_66700.n13 a_35349_66700.n9 11.3639
R1359 a_35349_66700.n12 a_35349_66700.t19 11.2114
R1360 a_35349_66700.n17 a_35349_66700.n16 10.7067
R1361 a_35349_66700.n13 a_35349_66700.n12 10.1465
R1362 a_35349_66700.n9 a_35349_66700.n8 9.6065
R1363 a_35349_66700.n12 a_35349_66700.n11 9.5165
R1364 a_35349_66700.n23 a_35349_66700.n22 9.0005
R1365 a_35349_66700.n2 a_35349_66700.t10 7.3005
R1366 a_35349_66700.n3 a_35349_66700.t9 7.3005
R1367 a_35349_66700.n18 a_35349_66700.t22 7.3005
R1368 a_35349_66700.n19 a_35349_66700.t23 7.3005
R1369 a_35349_66700.n5 a_35349_66700.t16 7.3005
R1370 a_35349_66700.n6 a_35349_66700.t15 7.3005
R1371 a_35349_66700.n14 a_35349_66700.t26 7.3005
R1372 a_35349_66700.n15 a_35349_66700.t27 7.3005
R1373 a_35349_66700.n24 a_35349_66700.n4 6.81272
R1374 a_35349_66700.n24 a_35349_66700.n23 5.1065
R1375 a_35349_66700.n1 a_35349_66700.n21 4.5005
R1376 a_35349_66700.n17 a_35349_66700.n13 4.3865
R1377 a_35349_66700.n22 a_35349_66700.t11 3.4183
R1378 a_35349_66700.n8 a_35349_66700.t17 3.4183
R1379 a_35349_66700.n1 a_35349_66700.t3 3.3074
R1380 a_35349_66700.n1 a_35349_66700.t4 3.13705
R1381 a_35349_66700.n22 a_35349_66700.t8 3.02615
R1382 a_35349_66700.n8 a_35349_66700.t14 3.02615
R1383 a_35349_66700.t6 a_35349_66700.t5 3.02455
R1384 a_35349_66700.n9 a_35349_66700.n7 1.20935
R1385 a_10640_5800.n11 a_10640_5800.n10 193.531
R1386 a_10640_5800.n1 a_10640_5800.t13 58.4912
R1387 a_10640_5800.n2 a_10640_5800.t8 58.4912
R1388 a_10640_5800.n1 a_10640_5800.t11 50.905
R1389 a_10640_5800.n2 a_10640_5800.t10 50.905
R1390 a_10640_5800.n11 a_10640_5800.n9 42.9485
R1391 a_10640_5800.n3 a_10640_5800.n2 34.9976
R1392 a_10640_5800.n3 a_10640_5800.n1 34.9976
R1393 a_10640_5800.n7 a_10640_5800.t7 30.1022
R1394 a_10640_5800.n12 a_10640_5800.t6 29.6942
R1395 a_10640_5800.n13 a_10640_5800.n12 21.6065
R1396 a_10640_5800.n9 a_10640_5800.n8 19.2425
R1397 a_10640_5800.n8 a_10640_5800.n7 18.7325
R1398 a_10640_5800.n6 a_10640_5800.n4 18.5165
R1399 a_10640_5800.n10 a_10640_5800.t18 18.2198
R1400 a_10640_5800.n10 a_10640_5800.t19 18.2198
R1401 a_10640_5800.n8 a_10640_5800.t0 16.9543
R1402 a_10640_5800.t16 a_10640_5800.n13 9.1865
R1403 a_10640_5800.n7 a_10640_5800.n6 9.0065
R1404 a_10640_5800.n12 a_10640_5800.n0 9.0005
R1405 a_10640_5800.n9 a_10640_5800.t5 7.76831
R1406 a_10640_5800.n6 a_10640_5800.n3 7.20588
R1407 a_10640_5800.n13 a_10640_5800.n11 5.2265
R1408 a_10640_5800.n6 a_10640_5800.n5 4.5005
R1409 a_10640_5800.t17 a_10640_5800.t16 3.87604
R1410 a_10640_5800.n0 a_10640_5800.t2 3.58581
R1411 a_10640_5800.n5 a_10640_5800.t12 3.23546
R1412 a_10640_5800.n4 a_10640_5800.t15 3.23546
R1413 a_10640_5800.n0 a_10640_5800.t4 3.07073
R1414 a_10640_5800.n0 a_10640_5800.t1 2.73081
R1415 a_10640_5800.n5 a_10640_5800.t9 2.73081
R1416 a_10640_5800.n4 a_10640_5800.t14 2.73081
R1417 a_10640_5800.n0 a_10640_5800.t3 2.72037
R1418 a_3080_5800.n11 a_3080_5800.n10 193.21
R1419 a_3080_5800.n1 a_3080_5800.t6 57.0573
R1420 a_3080_5800.n2 a_3080_5800.t1 57.0573
R1421 a_3080_5800.n1 a_3080_5800.t4 49.471
R1422 a_3080_5800.n2 a_3080_5800.t3 49.471
R1423 a_3080_5800.n11 a_3080_5800.n9 42.6725
R1424 a_3080_5800.n12 a_3080_5800.t9 28.6442
R1425 a_3080_5800.n14 a_3080_5800.n13 25.8965
R1426 a_3080_5800.n10 a_3080_5800.t18 22.8101
R1427 a_3080_5800.n10 a_3080_5800.t19 22.8101
R1428 a_3080_5800.n8 a_3080_5800.n7 21.837
R1429 a_3080_5800.n9 a_3080_5800.n8 18.6365
R1430 a_3080_5800.n6 a_3080_5800.n4 18.5165
R1431 a_3080_5800.n13 a_3080_5800.n12 18.1025
R1432 a_3080_5800.n12 a_3080_5800.t8 13.2362
R1433 a_3080_5800.n8 a_3080_5800.t0 12.8743
R1434 a_3080_5800.n9 a_3080_5800.t7 12.4543
R1435 a_3080_5800.t14 a_3080_5800.n14 9.0005
R1436 a_3080_5800.n7 a_3080_5800.n6 5.9465
R1437 a_3080_5800.n14 a_3080_5800.n11 5.6465
R1438 a_3080_5800.n13 a_3080_5800.n0 4.6865
R1439 a_3080_5800.n6 a_3080_5800.n5 4.5005
R1440 a_3080_5800.n3 a_3080_5800.n2 3.79364
R1441 a_3080_5800.n3 a_3080_5800.n1 3.79364
R1442 a_3080_5800.t15 a_3080_5800.t14 3.78376
R1443 a_3080_5800.n0 a_3080_5800.t12 3.51791
R1444 a_3080_5800.n0 a_3080_5800.t13 3.34675
R1445 a_3080_5800.n5 a_3080_5800.t5 3.16755
R1446 a_3080_5800.n4 a_3080_5800.t17 3.16755
R1447 a_3080_5800.n0 a_3080_5800.t10 3.00041
R1448 a_3080_5800.n5 a_3080_5800.t2 3.00041
R1449 a_3080_5800.n4 a_3080_5800.t16 3.00041
R1450 a_3080_5800.n0 a_3080_5800.t11 2.99639
R1451 a_3080_5800.n7 a_3080_5800.n3 1.88967
R1452 a_3989_67569.t5 a_3989_67569.t19 40.3211
R1453 a_3989_67569.n1 a_3989_67569.t20 31.9628
R1454 a_3989_67569.n2 a_3989_67569.t23 31.9628
R1455 a_3989_67569.n11 a_3989_67569.t12 31.9628
R1456 a_3989_67569.n12 a_3989_67569.t7 31.9628
R1457 a_3989_67569.n7 a_3989_67569.t5 30.0845
R1458 a_3989_67569.n5 a_3989_67569.t4 25.9873
R1459 a_3989_67569.n4 a_3989_67569.t24 22.8101
R1460 a_3989_67569.n4 a_3989_67569.t25 22.8101
R1461 a_3989_67569.n6 a_3989_67569.n5 22.6017
R1462 a_3989_67569.t13 a_3989_67569.n16 15.2765
R1463 a_3989_67569.n3 a_3989_67569.n1 12.3316
R1464 a_3989_67569.n3 a_3989_67569.n2 12.3316
R1465 a_3989_67569.n13 a_3989_67569.n11 12.3316
R1466 a_3989_67569.n13 a_3989_67569.n12 12.3316
R1467 a_3989_67569.n0 a_3989_67569.n13 10.8927
R1468 a_3989_67569.n0 a_3989_67569.n9 10.7765
R1469 a_3989_67569.n0 a_3989_67569.n10 9.3965
R1470 a_3989_67569.n14 a_3989_67569.n0 9.0725
R1471 a_3989_67569.n7 a_3989_67569.n6 8.4665
R1472 a_3989_67569.n16 a_3989_67569.n14 7.3265
R1473 a_3989_67569.n1 a_3989_67569.t21 7.3005
R1474 a_3989_67569.n2 a_3989_67569.t22 7.3005
R1475 a_3989_67569.n11 a_3989_67569.t10 7.3005
R1476 a_3989_67569.n12 a_3989_67569.t9 7.3005
R1477 a_3989_67569.n9 a_3989_67569.n7 6.9065
R1478 a_3989_67569.n6 a_3989_67569.t18 6.06839
R1479 a_3989_67569.n14 a_3989_67569.n3 6.06587
R1480 a_3989_67569.n9 a_3989_67569.n8 4.8965
R1481 a_3989_67569.t14 a_3989_67569.t13 4.5005
R1482 a_3989_67569.n16 a_3989_67569.n15 4.5005
R1483 a_3989_67569.n15 a_3989_67569.t1 3.4183
R1484 a_3989_67569.n10 a_3989_67569.t11 3.4183
R1485 a_3989_67569.n8 a_3989_67569.t2 3.4183
R1486 a_3989_67569.t16 a_3989_67569.t14 3.4183
R1487 a_3989_67569.n15 a_3989_67569.t3 3.02615
R1488 a_3989_67569.n10 a_3989_67569.t8 3.02615
R1489 a_3989_67569.n8 a_3989_67569.t0 3.02615
R1490 a_3989_67569.n5 a_3989_67569.n4 2.23383
R1491 a_4409_66700.n1 a_4409_66700.t20 31.9628
R1492 a_4409_66700.n2 a_4409_66700.t23 31.9628
R1493 a_4409_66700.n4 a_4409_66700.t5 31.9628
R1494 a_4409_66700.n5 a_4409_66700.t0 31.9628
R1495 a_4409_66700.n14 a_4409_66700.t24 31.9628
R1496 a_4409_66700.n15 a_4409_66700.t27 31.9628
R1497 a_4409_66700.n8 a_4409_66700.n7 22.8785
R1498 a_4409_66700.n11 a_4409_66700.t19 21.8962
R1499 a_4409_66700.n19 a_4409_66700.t11 21.0574
R1500 a_4409_66700.n12 a_4409_66700.n11 18.7565
R1501 a_4409_66700.n18 a_4409_66700.t28 18.2198
R1502 a_4409_66700.n18 a_4409_66700.t29 18.2198
R1503 a_4409_66700.n17 a_4409_66700.n13 16.0025
R1504 a_4409_66700.n20 a_4409_66700.n19 14.2025
R1505 a_4409_66700.n13 a_4409_66700.n3 12.4827
R1506 a_4409_66700.n3 a_4409_66700.n1 12.3316
R1507 a_4409_66700.n3 a_4409_66700.n2 12.3316
R1508 a_4409_66700.n6 a_4409_66700.n4 12.3316
R1509 a_4409_66700.n6 a_4409_66700.n5 12.3316
R1510 a_4409_66700.n16 a_4409_66700.n14 12.3316
R1511 a_4409_66700.n16 a_4409_66700.n15 12.3316
R1512 a_4409_66700.n0 a_4409_66700.n12 11.7065
R1513 a_4409_66700.t6 a_4409_66700.n21 11.3639
R1514 a_4409_66700.n20 a_4409_66700.t12 11.2114
R1515 a_4409_66700.n17 a_4409_66700.n16 10.7067
R1516 a_4409_66700.n11 a_4409_66700.t13 10.6809
R1517 a_4409_66700.n21 a_4409_66700.n20 10.1465
R1518 a_4409_66700.t7 a_4409_66700.t6 9.6065
R1519 a_4409_66700.n10 a_4409_66700.n9 9.0005
R1520 a_4409_66700.n1 a_4409_66700.t21 7.3005
R1521 a_4409_66700.n2 a_4409_66700.t22 7.3005
R1522 a_4409_66700.n4 a_4409_66700.t3 7.3005
R1523 a_4409_66700.n5 a_4409_66700.t2 7.3005
R1524 a_4409_66700.n14 a_4409_66700.t25 7.3005
R1525 a_4409_66700.n15 a_4409_66700.t26 7.3005
R1526 a_4409_66700.n19 a_4409_66700.n18 6.86883
R1527 a_4409_66700.n8 a_4409_66700.n6 6.81272
R1528 a_4409_66700.n10 a_4409_66700.n8 5.1065
R1529 a_4409_66700.n13 a_4409_66700.n0 4.5005
R1530 a_4409_66700.n21 a_4409_66700.n17 4.3865
R1531 a_4409_66700.n12 a_4409_66700.n10 3.5465
R1532 a_4409_66700.n7 a_4409_66700.t17 3.4199
R1533 a_4409_66700.n9 a_4409_66700.t4 3.4183
R1534 a_4409_66700.t9 a_4409_66700.t7 3.4183
R1535 a_4409_66700.n0 a_4409_66700.t15 3.3074
R1536 a_4409_66700.n0 a_4409_66700.t16 3.13705
R1537 a_4409_66700.n9 a_4409_66700.t1 3.02615
R1538 a_4409_66700.n7 a_4409_66700.t18 3.02455
R1539 a_11681_10659.n1 a_11681_10659.n12 190.319
R1540 a_11681_10659.n3 a_11681_10659.t12 58.4912
R1541 a_11681_10659.n4 a_11681_10659.t7 58.4912
R1542 a_11681_10659.n3 a_11681_10659.t10 50.905
R1543 a_11681_10659.n4 a_11681_10659.t9 50.905
R1544 a_11681_10659.n13 a_11681_10659.n11 36.3185
R1545 a_11681_10659.n13 a_11681_10659.n2 35.7125
R1546 a_11681_10659.n0 a_11681_10659.t2 35.1504
R1547 a_11681_10659.n0 a_11681_10659.n4 34.9976
R1548 a_11681_10659.n0 a_11681_10659.n3 34.9976
R1549 a_11681_10659.n10 a_11681_10659.n9 33.6425
R1550 a_11681_10659.n8 a_11681_10659.n6 33.3125
R1551 a_11681_10659.n11 a_11681_10659.n10 22.8545
R1552 a_11681_10659.n12 a_11681_10659.t18 18.2198
R1553 a_11681_10659.n12 a_11681_10659.t19 18.2198
R1554 a_11681_10659.n9 a_11681_10659.t17 14.2622
R1555 a_11681_10659.n9 a_11681_10659.n8 13.5065
R1556 a_11681_10659.n10 a_11681_10659.t1 12.2683
R1557 a_11681_10659.n11 a_11681_10659.t0 7.45031
R1558 a_11681_10659.n6 a_11681_10659.n0 7.20588
R1559 a_11681_10659.t15 a_11681_10659.n13 4.6865
R1560 a_11681_10659.n8 a_11681_10659.n7 4.5005
R1561 a_11681_10659.n6 a_11681_10659.n5 4.5005
R1562 a_11681_10659.n7 a_11681_10659.t14 3.23546
R1563 a_11681_10659.n5 a_11681_10659.t11 3.23546
R1564 a_11681_10659.t16 a_11681_10659.t15 3.03229
R1565 a_11681_10659.n2 a_11681_10659.t6 2.75492
R1566 a_11681_10659.n1 a_11681_10659.t3 2.73081
R1567 a_11681_10659.n7 a_11681_10659.t13 2.73081
R1568 a_11681_10659.n5 a_11681_10659.t8 2.73081
R1569 a_11681_10659.n1 a_11681_10659.t4 2.72037
R1570 a_11681_10659.n2 a_11681_10659.t5 2.72037
R1571 a_11681_10659.n2 a_11681_10659.n1 1.18175
R1572 a_12117_10659.n12 a_12117_10659.n11 199.495
R1573 a_12117_10659.n2 a_12117_10659.t7 57.0573
R1574 a_12117_10659.n3 a_12117_10659.t2 57.0573
R1575 a_12117_10659.n2 a_12117_10659.t5 49.471
R1576 a_12117_10659.n3 a_12117_10659.t4 49.471
R1577 a_12117_10659.n13 a_12117_10659.n10 37.0925
R1578 a_12117_10659.n1 a_12117_10659.n6 31.1043
R1579 a_12117_10659.n13 a_12117_10659.n12 28.1825
R1580 a_12117_10659.n11 a_12117_10659.t18 22.8101
R1581 a_12117_10659.n11 a_12117_10659.t19 22.8101
R1582 a_12117_10659.n7 a_12117_10659.t11 18.6722
R1583 a_12117_10659.n10 a_12117_10659.n9 18.5885
R1584 a_12117_10659.n7 a_12117_10659.n1 18.0065
R1585 a_12117_10659.n9 a_12117_10659.n8 17.8925
R1586 a_12117_10659.n9 a_12117_10659.t1 16.9543
R1587 a_12117_10659.n8 a_12117_10659.n7 15.5825
R1588 a_12117_10659.n6 a_12117_10659.n5 10.4465
R1589 a_12117_10659.t9 a_12117_10659.n13 9.8165
R1590 a_12117_10659.n8 a_12117_10659.t8 8.55019
R1591 a_12117_10659.n10 a_12117_10659.t0 7.45031
R1592 a_12117_10659.n12 a_12117_10659.n0 4.5005
R1593 a_12117_10659.n4 a_12117_10659.n3 3.79364
R1594 a_12117_10659.n4 a_12117_10659.n2 3.79364
R1595 a_12117_10659.n0 a_12117_10659.t14 3.34675
R1596 a_12117_10659.n0 a_12117_10659.t16 3.32505
R1597 a_12117_10659.n0 a_12117_10659.t17 3.19327
R1598 a_12117_10659.n1 a_12117_10659.t13 3.16755
R1599 a_12117_10659.n5 a_12117_10659.t6 3.16755
R1600 a_12117_10659.t10 a_12117_10659.t9 3.16501
R1601 a_12117_10659.n1 a_12117_10659.t12 3.00041
R1602 a_12117_10659.n5 a_12117_10659.t3 3.00041
R1603 a_12117_10659.n0 a_12117_10659.t15 2.99639
R1604 a_12117_10659.n6 a_12117_10659.n4 1.88967
C661 INN VSS 19.5229f
C662 INP VSS 46.57093f
C663 G3B VSS 27.6023f
C664 G3A VSS 28.8046f
C665 G2B VSS 20.60707f
C666 G2A VSS 18.5217f
C667 G1B VSS 36.09858f
C668 OUTP VSS 26.16931f
C669 OUTN VSS 31.98146f
C670 G1A VSS 32.81248f
C671 NB VSS 0.23555p
C672 VTN VSS 0.10084p
C673 VDD VSS 1.55435p
C674 a_5054_1400# VSS 0.38721f
C675 a_4644_1400# VSS 0.38371f
C676 a_3374_1400# VSS 0.38545f
C677 a_2964_1400# VSS 0.38462f ; **FLOATING
C678 a_1694_1400# VSS 0.38371f
C679 a_1284_1400# VSS 0.38721f ; **FLOATING
C680 a_73094_5740# VSS 0.38721f
C681 a_72684_5740# VSS 0.38371f ; **FLOATING
C682 a_71414_5740# VSS 0.38715f
C683 a_71004_5740# VSS 0.38362f
C684 a_69734_5740# VSS 0.38715f
C685 a_69324_5740# VSS 0.38365f
C686 a_68054_5740# VSS 0.38715f ; **FLOATING
C687 a_67644_5740# VSS 0.38362f ; **FLOATING
C688 a_66374_5740# VSS 0.38694f ; **FLOATING
C689 a_65964_5740# VSS 0.38365f ; **FLOATING
C690 a_64694_5740# VSS 0.38715f ; **FLOATING
C691 a_64284_5740# VSS 0.38362f ; **FLOATING
C692 a_63014_5740# VSS 0.38694f ; **FLOATING
C693 a_62604_5740# VSS 0.38365f ; **FLOATING
C694 a_61334_5740# VSS 0.38633f ; **FLOATING
C695 a_60924_5740# VSS 0.38365f ; **FLOATING
C696 a_59654_5740# VSS 0.38362f ; **FLOATING
C697 a_59244_5740# VSS 0.38365f ; **FLOATING
C698 a_57974_5740# VSS 0.38694f ; **FLOATING
C699 a_57564_5740# VSS 0.38362f ; **FLOATING
C700 a_56294_5740# VSS 0.38633f ; **FLOATING
C701 a_55884_5740# VSS 0.38365f ; **FLOATING
C702 a_54614_5740# VSS 0.38632f ; **FLOATING
C703 a_54204_5740# VSS 0.38348f ; **FLOATING
C704 a_52934_5740# VSS 0.38361f ; **FLOATING
C705 a_52524_5740# VSS 0.38364f ; **FLOATING
C706 a_51254_5740# VSS 0.38632f ; **FLOATING
C707 a_50844_5740# VSS 0.38364f ; **FLOATING
C708 a_49574_5740# VSS 0.38538f ; **FLOATING
C709 a_49164_5740# VSS 0.38394f ; **FLOATING
C710 a_47894_5740# VSS 0.38632f ; **FLOATING
C711 a_47484_5740# VSS 0.38364f ; **FLOATING
C712 a_46214_5740# VSS 0.38538f ; **FLOATING
C713 a_45804_5740# VSS 0.38394f ; **FLOATING
C714 a_44534_5740# VSS 0.38632f
C715 a_44124_5740# VSS 0.38364f ; **FLOATING
C716 a_42854_5740# VSS 0.38341f
C717 a_42444_5740# VSS 0.38632f ; **FLOATING
C718 a_41174_5740# VSS 0.38632f
C719 a_40764_5740# VSS 0.38426f
C720 a_39494_5740# VSS 0.38341f
C721 a_39084_5740# VSS 0.38714f ; **FLOATING
C722 a_37814_5740# VSS 0.07326f
C723 a_37404_5740# VSS 0.07326f
C724 a_36134_5740# VSS 0.07326f
C725 a_35724_5740# VSS 0.07326f
C726 a_34454_5740# VSS 0.07326f
C727 a_34044_5740# VSS 0.07326f
C728 a_32774_5740# VSS 0.07326f
C729 a_32364_5740# VSS 0.07326f
C730 a_30958_5740# VSS 0.1192f
C731 a_30260_5740# VSS 0.1192f
C732 a_28858_5740# VSS 1.26131f
C733 a_28160_5740# VSS 1.33975f
C734 a_26894_5740# VSS 0.07326f
C735 a_26484_5740# VSS 0.07326f
C736 a_25214_5740# VSS 0.07326f
C737 a_24804_5740# VSS 0.07326f
C738 a_23534_5740# VSS 0.07326f
C739 a_23124_5740# VSS 0.07326f
C740 a_21854_5740# VSS 0.07326f
C741 a_21444_5740# VSS 0.07326f
C742 a_20038_5740# VSS 0.1192f
C743 a_19340_5740# VSS 0.1192f
C744 a_17938_5740# VSS 1.25026f ; **FLOATING
C745 a_17240_5740# VSS 1.34166f ; **FLOATING
C746 a_15974_5740# VSS 0.07326f
C747 a_15564_5740# VSS 0.07326f
C748 a_14294_5740# VSS 0.07326f
C749 a_13884_5740# VSS 0.07326f
C750 a_12614_5740# VSS 0.07326f
C751 a_12204_5740# VSS 0.07326f
C752 a_10934_5740# VSS 0.07326f
C753 a_10524_5740# VSS 0.07326f
C754 a_9118_5740# VSS 0.1192f
C755 a_8420_5740# VSS 0.1192f
C756 a_7018_5740# VSS 1.25026f
C757 a_6320_5740# VSS 1.34702f
C758 a_5054_5740# VSS 0.07326f
C759 a_4644_5740# VSS 0.07326f
C760 a_3374_5740# VSS 0.07326f
C761 a_2964_5740# VSS 0.07326f
C762 a_1694_5740# VSS 0.07326f
C763 a_1284_5740# VSS 0.07326f
C764 a_72534_10360# VSS 0.07326f
C765 a_72124_10360# VSS 0.07326f
C766 a_70718_10360# VSS 0.1192f
C767 a_70020_10360# VSS 0.1192f
C768 a_68618_10360# VSS 1.26132f
C769 a_67920_10360# VSS 1.33976f
C770 a_66654_10360# VSS 0.07326f
C771 a_66244_10360# VSS 0.07326f
C772 a_64974_10360# VSS 0.07326f
C773 a_64564_10360# VSS 0.07326f
C774 a_63294_10360# VSS 0.07326f
C775 a_62884_10360# VSS 0.07326f
C776 a_61614_10360# VSS 0.07326f
C777 a_61204_10360# VSS 0.07326f
C778 a_59798_10360# VSS 0.1192f
C779 a_59100_10360# VSS 0.1192f
C780 a_57698_10360# VSS 1.26126f
C781 a_45947_6389# VSS 6.21298f ; **FLOATING
C782 a_57000_10360# VSS 1.3397f
C783 a_55734_10360# VSS 0.07326f
C784 a_55324_10360# VSS 0.07326f
C785 a_54054_10360# VSS 0.07326f
C786 a_53644_10360# VSS 0.07326f
C787 a_52374_10360# VSS 0.07326f
C788 a_51964_10360# VSS 0.07326f
C789 a_50558_10360# VSS 0.1192f
C790 a_49860_10360# VSS 0.1192f
C791 a_48458_10360# VSS 1.26126f
C792 a_39227_6389# VSS 3.56457f ; **FLOATING
C793 a_47760_10360# VSS 1.33056f
C794 a_46404_10599# VSS 0.82007f
C795 a_43564_10599# VSS 0.82007f
C796 a_42204_10599# VSS 0.82007f ; **FLOATING
C797 a_39364_10599# VSS 0.82007f ; **FLOATING
C798 a_38004_10599# VSS 0.82007f ; **FLOATING
C799 a_35164_10599# VSS 0.82007f ; **FLOATING
C800 a_33804_10599# VSS 0.82007f ; **FLOATING
C801 a_30964_10599# VSS 0.82007f ; **FLOATING
C802 a_29604_10599# VSS 0.82007f ; **FLOATING
C803 a_26764_10599# VSS 0.82007f ; **FLOATING
C804 a_25460_10599# VSS 0.147f
C805 a_3225_1460# VSS 8.05627f ; **FLOATING
C806 a_21668_10599# VSS 0.147f
C807 a_1545_1460# VSS 21.9464f ; **FLOATING
C808 a_20280_10599# VSS 0.147f
C809 a_16488_10599# VSS 0.147f
C810 a_15100_10599# VSS 0.147f
C811 a_11308_10599# VSS 0.147f
C812 a_9996_10599# VSS 0.147f
C813 a_7948_10599# VSS 0.147f
C814 a_6636_10599# VSS 0.147f
C815 a_4588_10599# VSS 0.147f
C816 a_3276_10599# VSS 0.147f
C817 a_1905_10449# VSS 20.5667f ; **FLOATING
C818 a_1228_10599# VSS 0.147f
C819 a_72016_15919# VSS 0.147f
C820 a_69968_15919# VSS 0.147f
C821 a_68656_15919# VSS 0.147f
C822 a_66608_15919# VSS 0.147f
C823 a_65296_15919# VSS 0.147f
C824 a_63248_15919# VSS 0.147f
C825 a_61936_15919# VSS 0.147f
C826 a_42705_5800# VSS 6.06603f ; **FLOATING
C827 a_59888_15919# VSS 0.147f
C828 a_58400_15924# VSS 2.63644f
C829 a_44073_10449# VSS 44.4123f ; **FLOATING
C830 a_43749_11849# VSS 48.2082f ; **FLOATING
C831 a_57160_18046# VSS 0.86356f ; **FLOATING
C832 a_56740_18046# VSS 0.85051f ; **FLOATING
C833 a_56320_15924# VSS 0.84725f ; **FLOATING
C834 a_55900_15924# VSS 0.85205f ; **FLOATING
C835 a_55480_18046# VSS 0.85871f ; **FLOATING
C836 a_55060_18046# VSS 0.85051f ; **FLOATING
C837 a_54640_15924# VSS 0.85871f ; **FLOATING
C838 a_54220_15924# VSS 0.85457f ; **FLOATING
C839 a_53800_18046# VSS 0.85871f ; **FLOATING
C840 a_53380_18046# VSS 0.85051f ; **FLOATING
C841 a_52960_15924# VSS 0.85871f ; **FLOATING
C842 a_52540_15924# VSS 0.85533f ; **FLOATING
C843 a_52120_18046# VSS 0.85871f ; **FLOATING
C844 a_51700_18046# VSS 0.85051f ; **FLOATING
C845 a_51280_15924# VSS 0.85871f ; **FLOATING
C846 a_50860_15924# VSS 0.85373f ; **FLOATING
C847 a_50440_18046# VSS 0.85871f ; **FLOATING
C848 a_50020_18046# VSS 0.85495f ; **FLOATING
C849 a_49620_15924# VSS 2.63799f ; **FLOATING
C850 a_48040_15924# VSS 2.63799f
C851 a_39873_10449# VSS 42.8282f ; **FLOATING
C852 a_39549_11849# VSS 51.2561f ; **FLOATING
C853 a_46800_18046# VSS 0.86356f ; **FLOATING
C854 a_46380_18046# VSS 0.85051f ; **FLOATING
C855 a_45960_15924# VSS 0.84725f ; **FLOATING
C856 a_45540_15924# VSS 0.85205f ; **FLOATING
C857 a_45120_18046# VSS 0.85871f ; **FLOATING
C858 a_44700_18046# VSS 0.85051f ; **FLOATING
C859 a_44280_15924# VSS 0.85871f ; **FLOATING
C860 a_43860_15924# VSS 0.85457f ; **FLOATING
C861 a_43440_18046# VSS 0.85871f ; **FLOATING
C862 a_43020_18046# VSS 0.85051f ; **FLOATING
C863 a_42600_15924# VSS 0.85871f ; **FLOATING
C864 a_42180_15924# VSS 0.85533f ; **FLOATING
C865 a_41760_18046# VSS 0.85871f ; **FLOATING
C866 a_41340_18046# VSS 0.85051f ; **FLOATING
C867 a_40920_15924# VSS 0.85871f ; **FLOATING
C868 a_40500_15924# VSS 0.85373f ; **FLOATING
C869 a_40080_18046# VSS 0.85871f ; **FLOATING
C870 a_39660_18046# VSS 0.85495f ; **FLOATING
C871 a_39260_15924# VSS 2.63799f ; **FLOATING
C872 a_37680_15924# VSS 2.63799f
C873 a_35673_10449# VSS 49.7464f ; **FLOATING
C874 a_35349_11849# VSS 50.2246f ; **FLOATING
C875 a_36440_18046# VSS 0.86356f ; **FLOATING
C876 a_36020_18046# VSS 0.85051f ; **FLOATING
C877 a_35600_15924# VSS 0.84725f ; **FLOATING
C878 a_35180_15924# VSS 0.85205f ; **FLOATING
C879 a_34760_18046# VSS 0.85871f ; **FLOATING
C880 a_34340_18046# VSS 0.85051f ; **FLOATING
C881 a_33920_15924# VSS 0.85871f ; **FLOATING
C882 a_33500_15924# VSS 0.85457f ; **FLOATING
C883 a_33080_18046# VSS 0.85871f ; **FLOATING
C884 a_32660_18046# VSS 0.85051f ; **FLOATING
C885 a_32240_15924# VSS 0.85871f ; **FLOATING
C886 a_31820_15924# VSS 0.85533f ; **FLOATING
C887 a_31400_18046# VSS 0.85871f ; **FLOATING
C888 a_30980_18046# VSS 0.85051f ; **FLOATING
C889 a_30560_15924# VSS 0.85871f ; **FLOATING
C890 a_30140_15924# VSS 0.85373f ; **FLOATING
C891 a_29720_18046# VSS 0.85871f ; **FLOATING
C892 a_29300_18046# VSS 0.85495f ; **FLOATING
C893 a_28900_15924# VSS 2.63799f ; **FLOATING
C894 a_27320_15924# VSS 2.63775f
C895 a_26920_15924# VSS 44.371f ; **FLOATING
C896 a_26500_15924# VSS 46.58689f ; **FLOATING
C897 a_26080_18046# VSS 0.86356f ; **FLOATING
C898 a_25660_18046# VSS 0.85051f ; **FLOATING
C899 a_25240_15924# VSS 0.8497f ; **FLOATING
C900 a_24820_15924# VSS 0.85205f ; **FLOATING
C901 a_24400_18046# VSS 0.85871f ; **FLOATING
C902 a_23980_18046# VSS 0.85051f ; **FLOATING
C903 a_23560_15924# VSS 0.85871f ; **FLOATING
C904 a_23140_15924# VSS 0.85457f ; **FLOATING
C905 a_22720_18046# VSS 0.85871f ; **FLOATING
C906 a_22300_18046# VSS 0.85051f ; **FLOATING
C907 a_21880_15924# VSS 0.85871f ; **FLOATING
C908 a_21460_15924# VSS 0.85533f ; **FLOATING
C909 a_21040_18046# VSS 0.85871f ; **FLOATING
C910 a_20620_18046# VSS 0.85051f ; **FLOATING
C911 a_20200_15924# VSS 0.85871f ; **FLOATING
C912 a_19780_15924# VSS 0.85373f ; **FLOATING
C913 a_19360_18046# VSS 0.85871f ; **FLOATING
C914 a_18940_18046# VSS 0.85495f ; **FLOATING
C915 a_18540_15924# VSS 2.63799f ; **FLOATING
C916 a_16960_15924# VSS 2.63775f
C917 a_16560_15924# VSS 48.4221f ; **FLOATING
C918 a_16140_15924# VSS 58.702f ; **FLOATING
C919 a_15720_18046# VSS 0.86356f ; **FLOATING
C920 a_15300_18046# VSS 0.85051f ; **FLOATING
C921 a_14880_15924# VSS 0.8497f ; **FLOATING
C922 a_14460_15924# VSS 0.85205f ; **FLOATING
C923 a_14040_18046# VSS 0.85871f ; **FLOATING
C924 a_13620_18046# VSS 0.85051f ; **FLOATING
C925 a_13200_15924# VSS 0.85871f ; **FLOATING
C926 a_12780_15924# VSS 0.85457f ; **FLOATING
C927 a_12360_18046# VSS 0.85871f ; **FLOATING
C928 a_11940_18046# VSS 0.85051f ; **FLOATING
C929 a_11520_15924# VSS 0.85871f ; **FLOATING
C930 a_11100_15924# VSS 0.85533f ; **FLOATING
C931 a_10680_18046# VSS 0.85871f ; **FLOATING
C932 a_10260_18046# VSS 0.85051f ; **FLOATING
C933 a_9840_15924# VSS 0.85871f ; **FLOATING
C934 a_9420_15924# VSS 0.85373f ; **FLOATING
C935 a_9000_18046# VSS 0.85871f ; **FLOATING
C936 a_8580_18046# VSS 0.85495f ; **FLOATING
C937 a_8180_15924# VSS 2.63799f
C938 a_6764_15680# VSS 0.14664f
C939 a_1228_15680# VSS 0.14664f
C940 a_6764_17191# VSS 0.14313f
C941 a_1228_17191# VSS 0.14313f
C942 a_71596_22499# VSS 0.147f
C943 a_69548_22499# VSS 0.147f
C944 a_67972_22260# VSS 3.49304f
C945 a_47140_22260# VSS 3.49154f
C946 a_67972_24191# VSS 3.41959f
C947 a_47140_24191# VSS 3.41959f
C948 a_67972_26151# VSS 3.42247f ; **FLOATING
C949 a_47140_26151# VSS 3.42247f
C950 a_67972_28111# VSS 3.46997f ; **FLOATING
C951 a_47140_28111# VSS 3.46997f
C952 a_72674_37100# VSS 0.07326f
C953 a_39345_5800# VSS 14.7402f ; **FLOATING
C954 a_72264_37100# VSS 0.07326f
C955 a_7428_39480# VSS 0.15163f
C956 a_6688_39480# VSS 0.15163f
C957 a_5064_39480# VSS 3.59083f ; **FLOATING
C958 a_3460_39480# VSS 3.60909f ; **FLOATING
C959 a_53816_62020# VSS 0.14314f
C960 a_51200_62020# VSS 0.14314f
C961 a_49616_62020# VSS 0.14314f
C962 a_47000_62020# VSS 0.14314f
C963 a_45416_62020# VSS 0.14314f
C964 a_42800_62020# VSS 0.14314f
C965 a_41216_62020# VSS 0.14314f
C966 a_38600_62020# VSS 0.14314f
C967 a_37016_62020# VSS 0.14314f
C968 a_34400_62020# VSS 0.14314f
C969 a_22876_62020# VSS 0.14314f
C970 a_20260_62020# VSS 0.14314f
C971 a_18676_62020# VSS 0.14314f
C972 a_16060_62020# VSS 0.14314f
C973 a_14476_62020# VSS 0.14314f
C974 a_11860_62020# VSS 0.14314f
C975 a_10276_62020# VSS 0.14314f
C976 a_7660_62020# VSS 0.14314f
C977 a_6076_62020# VSS 0.14314f
C978 a_3460_62020# VSS 0.14314f
C979 a_58016_66640# VSS 0.14314f
C980 a_55400_66640# VSS 0.14314f
C981 a_53816_66640# VSS 0.14314f
C982 a_51200_66640# VSS 0.14314f
C983 a_49616_66640# VSS 0.14314f
C984 a_47000_66640# VSS 0.14314f
C985 a_45416_66640# VSS 0.14314f
C986 a_42800_66640# VSS 0.14314f
C987 a_41216_66640# VSS 0.14314f
C988 a_38600_66640# VSS 0.14314f
C989 a_37016_66640# VSS 0.14314f
C990 a_34400_66640# VSS 0.14314f
C991 a_27076_66640# VSS 0.14314f
C992 a_24460_66640# VSS 0.14314f
C993 a_22876_66640# VSS 0.14314f
C994 a_20260_66640# VSS 0.14314f
C995 a_18676_66640# VSS 0.14314f
C996 a_16060_66640# VSS 0.14314f
C997 a_14476_66640# VSS 0.14314f
C998 a_11860_66640# VSS 0.14314f
C999 a_10276_66640# VSS 0.14314f
C1000 a_7660_66640# VSS 0.14314f
C1001 a_6076_66640# VSS 0.14314f
C1002 a_3460_66640# VSS 0.14314f
C1003 a_56896_71260# VSS 0.14314f
C1004 a_54280_71260# VSS 0.14314f
C1005 a_52696_71260# VSS 0.14314f
C1006 a_50080_71260# VSS 0.14314f
C1007 a_48496_71260# VSS 0.14314f
C1008 a_45880_71260# VSS 0.14314f
C1009 a_44296_71260# VSS 0.14314f
C1010 a_41680_71260# VSS 0.14314f
C1011 a_40096_71260# VSS 0.14314f
C1012 a_37480_71260# VSS 0.14314f
C1013 a_36076_71499# VSS 0.94318f
C1014 a_34460_71499# VSS 0.94318f
C1015 a_25956_71260# VSS 0.14314f
C1016 a_23340_71260# VSS 0.14314f
C1017 a_21756_71260# VSS 0.14314f
C1018 a_19140_71260# VSS 0.14314f
C1019 a_17556_71260# VSS 0.14314f
C1020 a_14940_71260# VSS 0.14314f
C1021 a_13356_71260# VSS 0.14314f
C1022 a_10740_71260# VSS 0.14314f
C1023 a_9156_71260# VSS 0.14314f
C1024 a_6540_71260# VSS 0.14314f
C1025 a_5136_71499# VSS 0.94673f
C1026 a_3520_71499# VSS 0.94673f
C1027 a_57496_76259# VSS 0.94673f
C1028 a_55880_76259# VSS 0.94673f
C1029 a_54416_76259# VSS 0.94673f
C1030 a_52800_76259# VSS 0.94673f
C1031 a_51184_76020# VSS 3.57465f
C1032 a_34720_71559# VSS 4.91717f ; **FLOATING
C1033 a_37373_76080# VSS 4.2945f ; **FLOATING
C1034 a_36361_76080# VSS 3.70313f ; **FLOATING
C1035 a_34400_76020# VSS 3.58224f ; **FLOATING
C1036 a_26556_76259# VSS 0.94318f
C1037 a_24940_76259# VSS 0.94673f
C1038 a_23476_76259# VSS 0.94673f
C1039 a_21860_76259# VSS 0.94673f
C1040 a_20244_76020# VSS 3.57465f
C1041 a_3780_71559# VSS 5.40221f ; **FLOATING
C1042 a_6433_76080# VSS 4.31207f ; **FLOATING
C1043 a_5421_76080# VSS 4.16099f ; **FLOATING
C1044 a_3460_76020# VSS 3.58224f ; **FLOATING
C1045 a_58756_81719# VSS 0.94673f
C1046 a_35349_76080# VSS 11.2682f ; **FLOATING
C1047 a_57140_81719# VSS 0.94673f
C1048 a_28516_81719# VSS 0.94599f
C1049 a_4409_76080# VSS 12.0099f ; **FLOATING
C1050 a_26900_81719# VSS 0.94599f
C1051 a_12117_10659.t10 VSS 0.51294f ; **FLOATING
C1052 a_12117_10659.n0 VSS 1.87868f ; **FLOATING
C1053 a_12117_10659.t6 VSS 0.6358f ; **FLOATING
C1054 a_12117_10659.t3 VSS 0.62303f ; **FLOATING
C1055 a_12117_10659.t13 VSS 0.62293f ; **FLOATING
C1056 a_12117_10659.t12 VSS 0.62303f ; **FLOATING
C1057 a_12117_10659.t17 VSS 0.63917f ; **FLOATING
C1058 a_12117_10659.t16 VSS 0.62293f ; **FLOATING
C1059 a_12117_10659.t15 VSS 0.62293f ; **FLOATING
C1060 a_12117_10659.t14 VSS 0.66624f ; **FLOATING
C1061 a_12117_10659.n1 VSS 2.59565f ; **FLOATING
C1062 a_12117_10659.t11 VSS 0.63646f ; **FLOATING
C1063 a_12117_10659.t7 VSS 0.43497f ; **FLOATING
C1064 a_12117_10659.t5 VSS 0.40897f ; **FLOATING
C1065 a_12117_10659.n2 VSS 0.36739f ; **FLOATING
C1066 a_12117_10659.t2 VSS 0.43497f ; **FLOATING
C1067 a_12117_10659.t4 VSS 0.40897f ; **FLOATING
C1068 a_12117_10659.n3 VSS 0.36739f ; **FLOATING
C1069 a_12117_10659.n4 VSS 0.13696f ; **FLOATING
C1070 a_12117_10659.n5 VSS 0.58699f ; **FLOATING
C1071 a_12117_10659.n6 VSS 2.08458f ; **FLOATING
C1072 a_12117_10659.n7 VSS 2.383f ; **FLOATING
C1073 a_12117_10659.t8 VSS 0.44379f ; **FLOATING
C1074 a_12117_10659.n8 VSS 1.63655f ; **FLOATING
C1075 a_12117_10659.t1 VSS 0.25897f ; **FLOATING
C1076 a_12117_10659.n9 VSS 1.98467f ; **FLOATING
C1077 a_12117_10659.t0 VSS 0.16573f ; **FLOATING
C1078 a_12117_10659.n10 VSS 2.25582f ; **FLOATING
C1079 a_12117_10659.t18 VSS 0.4751f ; **FLOATING
C1080 a_12117_10659.t19 VSS 0.4751f ; **FLOATING
C1081 a_12117_10659.n11 VSS 11.9278f ; **FLOATING
C1082 a_12117_10659.n12 VSS 13.7881f ; **FLOATING
C1083 a_12117_10659.n13 VSS 4.32856f ; **FLOATING
C1084 a_12117_10659.t9 VSS 3.1205f ; **FLOATING
C1085 a_11681_10659.n0 VSS 2.58005f ; **FLOATING
C1086 a_11681_10659.n1 VSS 12.6348f ; **FLOATING
C1087 a_11681_10659.t16 VSS 0.49223f ; **FLOATING
C1088 a_11681_10659.n2 VSS 2.58214f ; **FLOATING
C1089 a_11681_10659.t11 VSS 0.68673f ; **FLOATING
C1090 a_11681_10659.t8 VSS 0.60056f ; **FLOATING
C1091 a_11681_10659.t14 VSS 0.68673f ; **FLOATING
C1092 a_11681_10659.t13 VSS 0.60056f ; **FLOATING
C1093 a_11681_10659.t6 VSS 0.60146f ; **FLOATING
C1094 a_11681_10659.t5 VSS 0.60028f ; **FLOATING
C1095 a_11681_10659.t4 VSS 0.60028f ; **FLOATING
C1096 a_11681_10659.t3 VSS 0.60056f ; **FLOATING
C1097 a_11681_10659.t17 VSS 0.48383f ; **FLOATING
C1098 a_11681_10659.t2 VSS 1.81387f ; **FLOATING
C1099 a_11681_10659.t12 VSS 0.41913f ; **FLOATING
C1100 a_11681_10659.t10 VSS 0.3944f ; **FLOATING
C1101 a_11681_10659.n3 VSS 0.43345f ; **FLOATING
C1102 a_11681_10659.t7 VSS 0.41913f ; **FLOATING
C1103 a_11681_10659.t9 VSS 0.3944f ; **FLOATING
C1104 a_11681_10659.n4 VSS 0.43345f ; **FLOATING
C1105 a_11681_10659.n5 VSS 1.0186f ; **FLOATING
C1106 a_11681_10659.n6 VSS 1.66181f ; **FLOATING
C1107 a_11681_10659.n7 VSS 1.0186f ; **FLOATING
C1108 a_11681_10659.n8 VSS 2.64374f ; **FLOATING
C1109 a_11681_10659.n9 VSS 2.74457f ; **FLOATING
C1110 a_11681_10659.t1 VSS 0.21518f ; **FLOATING
C1111 a_11681_10659.n10 VSS 2.64597f ; **FLOATING
C1112 a_11681_10659.t0 VSS 0.15815f ; **FLOATING
C1113 a_11681_10659.n11 VSS 2.12883f ; **FLOATING
C1114 a_11681_10659.t18 VSS 0.43611f ; **FLOATING
C1115 a_11681_10659.t19 VSS 0.43611f ; **FLOATING
C1116 a_11681_10659.n12 VSS 11.1164f ; **FLOATING
C1117 a_11681_10659.n13 VSS 3.45755f ; **FLOATING
C1118 a_11681_10659.t15 VSS 3.39457f ; **FLOATING
C1119 a_4409_66700.t12 VSS 0.05353f ; **FLOATING
C1120 a_4409_66700.t11 VSS 0.11973f ; **FLOATING
C1121 a_4409_66700.t9 VSS 0.06864f ; **FLOATING
C1122 a_4409_66700.t18 VSS 0.06083f ; **FLOATING
C1123 a_4409_66700.t17 VSS 0.0687f ; **FLOATING
C1124 a_4409_66700.t4 VSS 0.06864f ; **FLOATING
C1125 a_4409_66700.t1 VSS 0.06084f ; **FLOATING
C1126 a_4409_66700.t16 VSS 0.06181f ; **FLOATING
C1127 a_4409_66700.t15 VSS 0.06084f ; **FLOATING
C1128 a_4409_66700.n0 VSS 0.14381f ; **FLOATING
C1129 a_4409_66700.t21 VSS 0.13607f ; **FLOATING
C1130 a_4409_66700.t20 VSS 0.19805f ; **FLOATING
C1131 a_4409_66700.n1 VSS 0.09195f ; **FLOATING
C1132 a_4409_66700.t22 VSS 0.13607f ; **FLOATING
C1133 a_4409_66700.t23 VSS 0.19805f ; **FLOATING
C1134 a_4409_66700.n2 VSS 0.09195f ; **FLOATING
C1135 a_4409_66700.n3 VSS 0.19481f ; **FLOATING
C1136 a_4409_66700.t3 VSS 0.13607f ; **FLOATING
C1137 a_4409_66700.t5 VSS 0.19805f ; **FLOATING
C1138 a_4409_66700.n4 VSS 0.09195f ; **FLOATING
C1139 a_4409_66700.t2 VSS 0.13607f ; **FLOATING
C1140 a_4409_66700.t0 VSS 0.19805f ; **FLOATING
C1141 a_4409_66700.n5 VSS 0.09195f ; **FLOATING
C1142 a_4409_66700.n6 VSS 0.15543f ; **FLOATING
C1143 a_4409_66700.n7 VSS 0.21484f ; **FLOATING
C1144 a_4409_66700.n8 VSS 0.14729f ; **FLOATING
C1145 a_4409_66700.n9 VSS 0.12971f ; **FLOATING
C1146 a_4409_66700.n10 VSS 0.05272f ; **FLOATING
C1147 a_4409_66700.t19 VSS 35.9735f ; **FLOATING
C1148 a_4409_66700.t13 VSS 3.34896f ; **FLOATING
C1149 a_4409_66700.n11 VSS 0.4331f ; **FLOATING
C1150 a_4409_66700.n12 VSS 0.20299f ; **FLOATING
C1151 a_4409_66700.n13 VSS 0.199f ; **FLOATING
C1152 a_4409_66700.t25 VSS 0.13607f ; **FLOATING
C1153 a_4409_66700.t24 VSS 0.19805f ; **FLOATING
C1154 a_4409_66700.n14 VSS 0.09195f ; **FLOATING
C1155 a_4409_66700.t26 VSS 0.13607f ; **FLOATING
C1156 a_4409_66700.t27 VSS 0.19805f ; **FLOATING
C1157 a_4409_66700.n15 VSS 0.09195f ; **FLOATING
C1158 a_4409_66700.n16 VSS 0.1612f ; **FLOATING
C1159 a_4409_66700.n17 VSS 0.20639f ; **FLOATING
C1160 a_4409_66700.t28 VSS 0.06706f ; **FLOATING
C1161 a_4409_66700.t29 VSS 0.06706f ; **FLOATING
C1162 a_4409_66700.n18 VSS 0.08363f ; **FLOATING
C1163 a_4409_66700.n19 VSS 0.23192f ; **FLOATING
C1164 a_4409_66700.n20 VSS 0.16644f ; **FLOATING
C1165 a_4409_66700.n21 VSS 0.11866f ; **FLOATING
C1166 a_4409_66700.t6 VSS 1.03429f ; **FLOATING
C1167 a_4409_66700.t7 VSS 0.19736f ; **FLOATING
C1168 a_3989_67569.n0 VSS 0.18135f ; **FLOATING
C1169 a_3989_67569.t18 VSS 0.04347f ; **FLOATING
C1170 a_3989_67569.t4 VSS 0.12682f ; **FLOATING
C1171 a_3989_67569.t16 VSS 0.06525f ; **FLOATING
C1172 a_3989_67569.t2 VSS 0.06525f ; **FLOATING
C1173 a_3989_67569.t0 VSS 0.05783f ; **FLOATING
C1174 a_3989_67569.t11 VSS 0.06525f ; **FLOATING
C1175 a_3989_67569.t8 VSS 0.05783f ; **FLOATING
C1176 a_3989_67569.t1 VSS 0.06525f ; **FLOATING
C1177 a_3989_67569.t3 VSS 0.05783f ; **FLOATING
C1178 a_3989_67569.t21 VSS 0.12935f ; **FLOATING
C1179 a_3989_67569.t20 VSS 0.18827f ; **FLOATING
C1180 a_3989_67569.n1 VSS 0.08741f ; **FLOATING
C1181 a_3989_67569.t22 VSS 0.12935f ; **FLOATING
C1182 a_3989_67569.t23 VSS 0.18827f ; **FLOATING
C1183 a_3989_67569.n2 VSS 0.08741f ; **FLOATING
C1184 a_3989_67569.n3 VSS 0.14587f ; **FLOATING
C1185 a_3989_67569.t19 VSS 34.3295f ; **FLOATING
C1186 a_3989_67569.t5 VSS 3.53384f ; **FLOATING
C1187 a_3989_67569.t24 VSS 0.06627f ; **FLOATING
C1188 a_3989_67569.t25 VSS 0.06627f ; **FLOATING
C1189 a_3989_67569.n4 VSS 0.06555f ; **FLOATING
C1190 a_3989_67569.n5 VSS 0.22086f ; **FLOATING
C1191 a_3989_67569.n6 VSS 0.12496f ; **FLOATING
C1192 a_3989_67569.n7 VSS 0.26277f ; **FLOATING
C1193 a_3989_67569.n8 VSS 0.12236f ; **FLOATING
C1194 a_3989_67569.n9 VSS 0.11493f ; **FLOATING
C1195 a_3989_67569.n10 VSS 0.12772f ; **FLOATING
C1196 a_3989_67569.t10 VSS 0.12935f ; **FLOATING
C1197 a_3989_67569.t12 VSS 0.18827f ; **FLOATING
C1198 a_3989_67569.n11 VSS 0.08741f ; **FLOATING
C1199 a_3989_67569.t9 VSS 0.12935f ; **FLOATING
C1200 a_3989_67569.t7 VSS 0.18827f ; **FLOATING
C1201 a_3989_67569.n12 VSS 0.08741f ; **FLOATING
C1202 a_3989_67569.n13 VSS 0.15538f ; **FLOATING
C1203 a_3989_67569.n14 VSS 0.11249f ; **FLOATING
C1204 a_3989_67569.n15 VSS 0.12189f ; **FLOATING
C1205 a_3989_67569.n16 VSS 0.13719f ; **FLOATING
C1206 a_3989_67569.t13 VSS 2.10409f ; **FLOATING
C1207 a_3989_67569.t14 VSS 0.17973f ; **FLOATING
C1208 a_3080_5800.n0 VSS 2.21281f ; **FLOATING
C1209 a_3080_5800.t14 VSS 3.54194f ; **FLOATING
C1210 a_3080_5800.t15 VSS 0.62748f ; **FLOATING
C1211 a_3080_5800.t17 VSS 0.74208f ; **FLOATING
C1212 a_3080_5800.t16 VSS 0.72717f ; **FLOATING
C1213 a_3080_5800.t5 VSS 0.74208f ; **FLOATING
C1214 a_3080_5800.t2 VSS 0.72717f ; **FLOATING
C1215 a_3080_5800.t13 VSS 0.77761f ; **FLOATING
C1216 a_3080_5800.t12 VSS 0.72705f ; **FLOATING
C1217 a_3080_5800.t11 VSS 0.72705f ; **FLOATING
C1218 a_3080_5800.t10 VSS 0.72717f ; **FLOATING
C1219 a_3080_5800.t7 VSS 0.25342f ; **FLOATING
C1220 a_3080_5800.t6 VSS 0.50768f ; **FLOATING
C1221 a_3080_5800.t4 VSS 0.47734f ; **FLOATING
C1222 a_3080_5800.n1 VSS 0.4288f ; **FLOATING
C1223 a_3080_5800.t1 VSS 0.50768f ; **FLOATING
C1224 a_3080_5800.t3 VSS 0.47734f ; **FLOATING
C1225 a_3080_5800.n2 VSS 0.4288f ; **FLOATING
C1226 a_3080_5800.n3 VSS 0.15985f ; **FLOATING
C1227 a_3080_5800.n4 VSS 0.89185f ; **FLOATING
C1228 a_3080_5800.n5 VSS 0.55024f ; **FLOATING
C1229 a_3080_5800.n6 VSS 0.77424f ; **FLOATING
C1230 a_3080_5800.n7 VSS 1.60321f ; **FLOATING
C1231 a_3080_5800.t0 VSS 0.28303f ; **FLOATING
C1232 a_3080_5800.n8 VSS 2.64762f ; **FLOATING
C1233 a_3080_5800.n9 VSS 3.942f ; **FLOATING
C1234 a_3080_5800.t18 VSS 0.55452f ; **FLOATING
C1235 a_3080_5800.t19 VSS 0.55452f ; **FLOATING
C1236 a_3080_5800.n10 VSS 13.5204f ; **FLOATING
C1237 a_3080_5800.n11 VSS 16.8391f ; **FLOATING
C1238 a_3080_5800.t9 VSS 1.3966f ; **FLOATING
C1239 a_3080_5800.t8 VSS 0.57674f ; **FLOATING
C1240 a_3080_5800.n12 VSS 3.03459f ; **FLOATING
C1241 a_3080_5800.n13 VSS 2.70238f ; **FLOATING
C1242 a_3080_5800.n14 VSS 2.54591f ; **FLOATING
C1243 a_10640_5800.n0 VSS 3.0601f ; **FLOATING
C1244 a_10640_5800.t16 VSS 4.24811f ; **FLOATING
C1245 a_10640_5800.t17 VSS 0.64559f ; **FLOATING
C1246 a_10640_5800.t15 VSS 0.85915f ; **FLOATING
C1247 a_10640_5800.t14 VSS 0.75134f ; **FLOATING
C1248 a_10640_5800.t12 VSS 0.85915f ; **FLOATING
C1249 a_10640_5800.t9 VSS 0.75134f ; **FLOATING
C1250 a_10640_5800.t4 VSS 0.80654f ; **FLOATING
C1251 a_10640_5800.t3 VSS 0.751f ; **FLOATING
C1252 a_10640_5800.t2 VSS 0.751f ; **FLOATING
C1253 a_10640_5800.t1 VSS 0.75134f ; **FLOATING
C1254 a_10640_5800.t5 VSS 0.20335f ; **FLOATING
C1255 a_10640_5800.t13 VSS 0.52437f ; **FLOATING
C1256 a_10640_5800.t11 VSS 0.49342f ; **FLOATING
C1257 a_10640_5800.n1 VSS 0.54229f ; **FLOATING
C1258 a_10640_5800.t8 VSS 0.52437f ; **FLOATING
C1259 a_10640_5800.t10 VSS 0.49342f ; **FLOATING
C1260 a_10640_5800.n2 VSS 0.54229f ; **FLOATING
C1261 a_10640_5800.n3 VSS 1.18712f ; **FLOATING
C1262 a_10640_5800.n4 VSS 1.62378f ; **FLOATING
C1263 a_10640_5800.n5 VSS 1.27435f ; **FLOATING
C1264 a_10640_5800.n6 VSS 1.62024f ; **FLOATING
C1265 a_10640_5800.t7 VSS 1.40014f ; **FLOATING
C1266 a_10640_5800.n7 VSS 3.38341f ; **FLOATING
C1267 a_10640_5800.t0 VSS 0.31811f ; **FLOATING
C1268 a_10640_5800.n8 VSS 2.61831f ; **FLOATING
C1269 a_10640_5800.n9 VSS 3.14212f ; **FLOATING
C1270 a_10640_5800.t18 VSS 0.54561f ; **FLOATING
C1271 a_10640_5800.t19 VSS 0.54561f ; **FLOATING
C1272 a_10640_5800.n10 VSS 13.5752f ; **FLOATING
C1273 a_10640_5800.n11 VSS 17.328f ; **FLOATING
C1274 a_10640_5800.t6 VSS 1.68187f ; **FLOATING
C1275 a_10640_5800.n12 VSS 3.63705f ; **FLOATING
C1276 a_10640_5800.n13 VSS 2.29195f ; **FLOATING
C1277 a_35349_66700.n0 VSS 0.64549f ; **FLOATING
C1278 a_35349_66700.t19 VSS 0.08773f ; **FLOATING
C1279 a_35349_66700.t0 VSS 0.0871f ; **FLOATING
C1280 a_35349_66700.t6 VSS 0.09969f ; **FLOATING
C1281 a_35349_66700.t17 VSS 0.11248f ; **FLOATING
C1282 a_35349_66700.t14 VSS 0.0997f ; **FLOATING
C1283 a_35349_66700.t4 VSS 0.10129f ; **FLOATING
C1284 a_35349_66700.t3 VSS 0.0997f ; **FLOATING
C1285 a_35349_66700.t11 VSS 0.11248f ; **FLOATING
C1286 a_35349_66700.t8 VSS 0.0997f ; **FLOATING
C1287 a_35349_66700.n1 VSS 0.26969f ; **FLOATING
C1288 a_35349_66700.t10 VSS 0.22298f ; **FLOATING
C1289 a_35349_66700.t12 VSS 0.32455f ; **FLOATING
C1290 a_35349_66700.n2 VSS 0.15068f ; **FLOATING
C1291 a_35349_66700.t9 VSS 0.22298f ; **FLOATING
C1292 a_35349_66700.t7 VSS 0.32455f ; **FLOATING
C1293 a_35349_66700.n3 VSS 0.15068f ; **FLOATING
C1294 a_35349_66700.n4 VSS 0.2547f ; **FLOATING
C1295 a_35349_66700.t16 VSS 0.22298f ; **FLOATING
C1296 a_35349_66700.t18 VSS 0.32455f ; **FLOATING
C1297 a_35349_66700.n5 VSS 0.15068f ; **FLOATING
C1298 a_35349_66700.t15 VSS 0.22298f ; **FLOATING
C1299 a_35349_66700.t13 VSS 0.32455f ; **FLOATING
C1300 a_35349_66700.n6 VSS 0.15068f ; **FLOATING
C1301 a_35349_66700.n7 VSS 0.15076f ; **FLOATING
C1302 a_35349_66700.n8 VSS 0.22372f ; **FLOATING
C1303 a_35349_66700.n9 VSS 0.14772f ; **FLOATING
C1304 a_35349_66700.t20 VSS 25.1984f ; **FLOATING
C1305 a_35349_66700.t1 VSS 3.81042f ; **FLOATING
C1306 a_35349_66700.t29 VSS 0.10989f ; **FLOATING
C1307 a_35349_66700.t30 VSS 0.10989f ; **FLOATING
C1308 a_35349_66700.n10 VSS 0.14946f ; **FLOATING
C1309 a_35349_66700.n11 VSS 0.25683f ; **FLOATING
C1310 a_35349_66700.n12 VSS 0.22985f ; **FLOATING
C1311 a_35349_66700.n13 VSS 0.19444f ; **FLOATING
C1312 a_35349_66700.t26 VSS 0.22298f ; **FLOATING
C1313 a_35349_66700.t25 VSS 0.32455f ; **FLOATING
C1314 a_35349_66700.n14 VSS 0.15068f ; **FLOATING
C1315 a_35349_66700.t27 VSS 0.22298f ; **FLOATING
C1316 a_35349_66700.t28 VSS 0.32455f ; **FLOATING
C1317 a_35349_66700.n15 VSS 0.15068f ; **FLOATING
C1318 a_35349_66700.n16 VSS 0.26416f ; **FLOATING
C1319 a_35349_66700.n17 VSS 0.33821f ; **FLOATING
C1320 a_35349_66700.t22 VSS 0.22298f ; **FLOATING
C1321 a_35349_66700.t21 VSS 0.32455f ; **FLOATING
C1322 a_35349_66700.n18 VSS 0.15068f ; **FLOATING
C1323 a_35349_66700.t23 VSS 0.22298f ; **FLOATING
C1324 a_35349_66700.t24 VSS 0.32455f ; **FLOATING
C1325 a_35349_66700.n19 VSS 0.15068f ; **FLOATING
C1326 a_35349_66700.n20 VSS 0.31925f ; **FLOATING
C1327 a_35349_66700.n21 VSS 0.3261f ; **FLOATING
C1328 a_35349_66700.n22 VSS 0.21256f ; **FLOATING
C1329 a_35349_66700.n23 VSS 0.19839f ; **FLOATING
C1330 a_35349_66700.n24 VSS 0.24137f ; **FLOATING
C1331 a_35349_66700.t5 VSS 0.46464f ; **FLOATING
C1332 a_34929_67569.n0 VSS 0.3149f ; **FLOATING
C1333 a_34929_67569.t4 VSS 0.07549f ; **FLOATING
C1334 a_34929_67569.t2 VSS 0.13656f ; **FLOATING
C1335 a_34929_67569.t14 VSS 0.11331f ; **FLOATING
C1336 a_34929_67569.t3 VSS 0.11331f ; **FLOATING
C1337 a_34929_67569.t0 VSS 0.10042f ; **FLOATING
C1338 a_34929_67569.t9 VSS 0.11331f ; **FLOATING
C1339 a_34929_67569.t6 VSS 0.10042f ; **FLOATING
C1340 a_34929_67569.t20 VSS 0.22461f ; **FLOATING
C1341 a_34929_67569.t19 VSS 0.32692f ; **FLOATING
C1342 a_34929_67569.n1 VSS 0.15178f ; **FLOATING
C1343 a_34929_67569.t21 VSS 0.22461f ; **FLOATING
C1344 a_34929_67569.t22 VSS 0.32692f ; **FLOATING
C1345 a_34929_67569.n2 VSS 0.15178f ; **FLOATING
C1346 a_34929_67569.n3 VSS 0.25329f ; **FLOATING
C1347 a_34929_67569.t18 VSS 25.4572f ; **FLOATING
C1348 a_34929_67569.t16 VSS 3.62894f ; **FLOATING
C1349 a_34929_67569.n4 VSS 0.24617f ; **FLOATING
C1350 a_34929_67569.t23 VSS 0.11507f ; **FLOATING
C1351 a_34929_67569.t24 VSS 0.11507f ; **FLOATING
C1352 a_34929_67569.n5 VSS 0.15055f ; **FLOATING
C1353 a_34929_67569.n6 VSS 0.2219f ; **FLOATING
C1354 a_34929_67569.n7 VSS 0.19615f ; **FLOATING
C1355 a_34929_67569.n8 VSS 0.53479f ; **FLOATING
C1356 a_34929_67569.n9 VSS 0.21248f ; **FLOATING
C1357 a_34929_67569.n10 VSS 0.19957f ; **FLOATING
C1358 a_34929_67569.n11 VSS 0.22178f ; **FLOATING
C1359 a_34929_67569.t8 VSS 0.22461f ; **FLOATING
C1360 a_34929_67569.t10 VSS 0.32692f ; **FLOATING
C1361 a_34929_67569.n12 VSS 0.15178f ; **FLOATING
C1362 a_34929_67569.t7 VSS 0.22461f ; **FLOATING
C1363 a_34929_67569.t5 VSS 0.32692f ; **FLOATING
C1364 a_34929_67569.n13 VSS 0.15178f ; **FLOATING
C1365 a_34929_67569.n14 VSS 0.2698f ; **FLOATING
C1366 a_34929_67569.n15 VSS 0.19534f ; **FLOATING
C1367 a_34929_67569.t1 VSS 0.66361f ; **FLOATING
C1368 a_34929_67569.t11 VSS 3.65363f ; **FLOATING
C1369 a_34929_67569.t12 VSS 0.31208f ; **FLOATING
C1370 a_3849_72329.t0 VSS 0.18513f ; **FLOATING
C1371 a_3849_72329.t11 VSS 0.15184f ; **FLOATING
C1372 a_3849_72329.t18 VSS 0.14783f ; **FLOATING
C1373 a_3849_72329.t17 VSS 0.13538f ; **FLOATING
C1374 a_3849_72329.t7 VSS 0.14783f ; **FLOATING
C1375 a_3849_72329.t4 VSS 0.13538f ; **FLOATING
C1376 a_3849_72329.t20 VSS 0.15184f ; **FLOATING
C1377 a_3849_72329.t19 VSS 0.13458f ; **FLOATING
C1378 a_3849_72329.t23 VSS 0.301f ; **FLOATING
C1379 a_3849_72329.t22 VSS 0.43811f ; **FLOATING
C1380 a_3849_72329.n0 VSS 0.2034f ; **FLOATING
C1381 a_3849_72329.t24 VSS 0.301f ; **FLOATING
C1382 a_3849_72329.t25 VSS 0.43811f ; **FLOATING
C1383 a_3849_72329.n1 VSS 0.2034f ; **FLOATING
C1384 a_3849_72329.n2 VSS 0.41438f ; **FLOATING
C1385 a_3849_72329.t6 VSS 0.301f ; **FLOATING
C1386 a_3849_72329.t8 VSS 0.43811f ; **FLOATING
C1387 a_3849_72329.n3 VSS 0.2034f ; **FLOATING
C1388 a_3849_72329.t5 VSS 0.301f ; **FLOATING
C1389 a_3849_72329.t3 VSS 0.43811f ; **FLOATING
C1390 a_3849_72329.n4 VSS 0.2034f ; **FLOATING
C1391 a_3849_72329.n5 VSS 0.3437f ; **FLOATING
C1392 a_3849_72329.t21 VSS 22.2233f ; **FLOATING
C1393 a_3849_72329.t15 VSS 4.08353f ; **FLOATING
C1394 a_3849_72329.n6 VSS 0.42178f ; **FLOATING
C1395 a_3849_72329.t13 VSS 14.6415f ; **FLOATING
C1396 a_3849_72329.n7 VSS 2.18499f ; **FLOATING
C1397 a_3849_72329.t26 VSS 0.15421f ; **FLOATING
C1398 a_3849_72329.t27 VSS 0.15421f ; **FLOATING
C1399 a_3849_72329.n8 VSS 0.15255f ; **FLOATING
C1400 a_3849_72329.n9 VSS 0.13338f ; **FLOATING
C1401 a_3849_72329.n10 VSS 0.61391f ; **FLOATING
C1402 a_3849_72329.n11 VSS 0.29015f ; **FLOATING
C1403 a_3849_72329.n12 VSS 0.51298f ; **FLOATING
C1404 a_3849_72329.n13 VSS 0.28686f ; **FLOATING
C1405 a_3849_72329.n14 VSS 0.36144f ; **FLOATING
C1406 a_3849_72329.n15 VSS 0.47016f ; **FLOATING
C1407 a_3849_72329.n16 VSS 0.29721f ; **FLOATING
C1408 a_3849_72329.n17 VSS 0.30706f ; **FLOATING
C1409 a_3849_72329.t1 VSS 6.33476f ; **FLOATING
C1410 a_3849_72329.t9 VSS 0.43179f ; **FLOATING
C1411 a_4409_62080.n0 VSS 0.69525f ; **FLOATING
C1412 a_4409_62080.t0 VSS 0.11261f ; **FLOATING
C1413 a_4409_62080.t18 VSS 0.14854f ; **FLOATING
C1414 a_4409_62080.t14 VSS 0.14854f ; **FLOATING
C1415 a_4409_62080.t11 VSS 0.13165f ; **FLOATING
C1416 a_4409_62080.t4 VSS 0.14854f ; **FLOATING
C1417 a_4409_62080.t5 VSS 0.13165f ; **FLOATING
C1418 a_4409_62080.t13 VSS 0.29446f ; **FLOATING
C1419 a_4409_62080.t15 VSS 0.42858f ; **FLOATING
C1420 a_4409_62080.n1 VSS 0.19897f ; **FLOATING
C1421 a_4409_62080.t12 VSS 0.29446f ; **FLOATING
C1422 a_4409_62080.t10 VSS 0.42858f ; **FLOATING
C1423 a_4409_62080.n2 VSS 0.19897f ; **FLOATING
C1424 a_4409_62080.n3 VSS 0.19909f ; **FLOATING
C1425 a_4409_62080.t6 VSS 13.6481f ; **FLOATING
C1426 a_4409_62080.t20 VSS 21.8981f ; **FLOATING
C1427 a_4409_62080.t2 VSS 3.93096f ; **FLOATING
C1428 a_4409_62080.n4 VSS 0.60193f ; **FLOATING
C1429 a_4409_62080.t25 VSS 0.14511f ; **FLOATING
C1430 a_4409_62080.t26 VSS 0.14511f ; **FLOATING
C1431 a_4409_62080.n5 VSS 0.26113f ; **FLOATING
C1432 a_4409_62080.n6 VSS 1.76345f ; **FLOATING
C1433 a_4409_62080.n7 VSS 0.27961f ; **FLOATING
C1434 a_4409_62080.n8 VSS 0.15517f ; **FLOATING
C1435 a_4409_62080.n9 VSS 0.26838f ; **FLOATING
C1436 a_4409_62080.t22 VSS 0.29446f ; **FLOATING
C1437 a_4409_62080.t21 VSS 0.42858f ; **FLOATING
C1438 a_4409_62080.n10 VSS 0.19897f ; **FLOATING
C1439 a_4409_62080.t23 VSS 0.29446f ; **FLOATING
C1440 a_4409_62080.t24 VSS 0.42858f ; **FLOATING
C1441 a_4409_62080.n11 VSS 0.19897f ; **FLOATING
C1442 a_4409_62080.n12 VSS 0.33068f ; **FLOATING
C1443 a_4409_62080.n13 VSS 0.37366f ; **FLOATING
C1444 a_4409_62080.n14 VSS 0.27748f ; **FLOATING
C1445 a_4409_62080.n15 VSS 0.31698f ; **FLOATING
C1446 a_4409_62080.t1 VSS 7.23127f ; **FLOATING
C1447 a_4409_62080.t16 VSS 0.40913f ; **FLOATING
C1448 a_34789_72329.n0 VSS 0.25501f ; **FLOATING
C1449 a_34789_72329.t0 VSS 0.08589f ; **FLOATING
C1450 a_34789_72329.t22 VSS 0.07396f ; **FLOATING
C1451 a_34789_72329.t6 VSS 0.11092f ; **FLOATING
C1452 a_34789_72329.t4 VSS 0.10799f ; **FLOATING
C1453 a_34789_72329.t3 VSS 0.09889f ; **FLOATING
C1454 a_34789_72329.t13 VSS 0.10799f ; **FLOATING
C1455 a_34789_72329.t10 VSS 0.09889f ; **FLOATING
C1456 a_34789_72329.t19 VSS 0.11092f ; **FLOATING
C1457 a_34789_72329.t16 VSS 0.09831f ; **FLOATING
C1458 a_34789_72329.t26 VSS 0.21988f ; **FLOATING
C1459 a_34789_72329.t25 VSS 0.32004f ; **FLOATING
C1460 a_34789_72329.n1 VSS 0.14858f ; **FLOATING
C1461 a_34789_72329.t27 VSS 0.21988f ; **FLOATING
C1462 a_34789_72329.t28 VSS 0.32004f ; **FLOATING
C1463 a_34789_72329.n2 VSS 0.14858f ; **FLOATING
C1464 a_34789_72329.n3 VSS 0.3027f ; **FLOATING
C1465 a_34789_72329.t12 VSS 0.21988f ; **FLOATING
C1466 a_34789_72329.t14 VSS 0.32004f ; **FLOATING
C1467 a_34789_72329.n4 VSS 0.14858f ; **FLOATING
C1468 a_34789_72329.t11 VSS 0.21988f ; **FLOATING
C1469 a_34789_72329.t9 VSS 0.32004f ; **FLOATING
C1470 a_34789_72329.n5 VSS 0.14858f ; **FLOATING
C1471 a_34789_72329.n6 VSS 0.25107f ; **FLOATING
C1472 a_34789_72329.t33 VSS 0.11265f ; **FLOATING
C1473 a_34789_72329.t34 VSS 0.11265f ; **FLOATING
C1474 a_34789_72329.n7 VSS 0.15086f ; **FLOATING
C1475 a_34789_72329.t7 VSS 10.4812f ; **FLOATING
C1476 a_34789_72329.n8 VSS 1.4116f ; **FLOATING
C1477 a_34789_72329.n9 VSS 0.42447f ; **FLOATING
C1478 a_34789_72329.n10 VSS 0.21196f ; **FLOATING
C1479 a_34789_72329.n11 VSS 0.37473f ; **FLOATING
C1480 a_34789_72329.n12 VSS 0.20955f ; **FLOATING
C1481 a_34789_72329.n13 VSS 0.26403f ; **FLOATING
C1482 a_34789_72329.n14 VSS 0.34345f ; **FLOATING
C1483 a_34789_72329.t24 VSS 41.2468f ; **FLOATING
C1484 a_34789_72329.t1 VSS 4.60183f ; **FLOATING
C1485 a_34789_72329.n15 VSS 0.68181f ; **FLOATING
C1486 a_34789_72329.t23 VSS 0.11265f ; **FLOATING
C1487 a_34789_72329.t21 VSS 0.11265f ; **FLOATING
C1488 a_34789_72329.n16 VSS 0.14742f ; **FLOATING
C1489 a_34789_72329.n17 VSS 0.32014f ; **FLOATING
C1490 a_34789_72329.n18 VSS 0.2472f ; **FLOATING
C1491 a_34789_72329.t30 VSS 0.21988f ; **FLOATING
C1492 a_34789_72329.t29 VSS 0.32004f ; **FLOATING
C1493 a_34789_72329.n19 VSS 0.14858f ; **FLOATING
C1494 a_34789_72329.t31 VSS 0.21988f ; **FLOATING
C1495 a_34789_72329.t32 VSS 0.32004f ; **FLOATING
C1496 a_34789_72329.n20 VSS 0.14858f ; **FLOATING
C1497 a_34789_72329.n21 VSS 0.2477f ; **FLOATING
C1498 a_34789_72329.n22 VSS 0.36418f ; **FLOATING
C1499 a_34789_72329.t18 VSS 0.21988f ; **FLOATING
C1500 a_34789_72329.t20 VSS 0.32004f ; **FLOATING
C1501 a_34789_72329.n23 VSS 0.14858f ; **FLOATING
C1502 a_34789_72329.t17 VSS 0.21988f ; **FLOATING
C1503 a_34789_72329.t15 VSS 0.32004f ; **FLOATING
C1504 a_34789_72329.n24 VSS 0.14858f ; **FLOATING
C1505 a_34789_72329.n25 VSS 0.26412f ; **FLOATING
C1506 a_34789_72329.n26 VSS 0.21711f ; **FLOATING
C1507 a_34789_72329.n27 VSS 0.2243f ; **FLOATING
C1508 a_34789_72329.t5 VSS 0.31542f ; **FLOATING
C1509 a_35349_62080.t0 VSS 0.07127f ; **FLOATING
C1510 a_35349_62080.t10 VSS 0.09162f ; **FLOATING
C1511 a_35349_62080.t5 VSS 0.09162f ; **FLOATING
C1512 a_35349_62080.t2 VSS 0.0812f ; **FLOATING
C1513 a_35349_62080.t15 VSS 0.09162f ; **FLOATING
C1514 a_35349_62080.t14 VSS 0.0812f ; **FLOATING
C1515 a_35349_62080.t4 VSS 0.18161f ; **FLOATING
C1516 a_35349_62080.t6 VSS 0.26434f ; **FLOATING
C1517 a_35349_62080.n0 VSS 0.12272f ; **FLOATING
C1518 a_35349_62080.t3 VSS 0.18161f ; **FLOATING
C1519 a_35349_62080.t1 VSS 0.26434f ; **FLOATING
C1520 a_35349_62080.n1 VSS 0.12272f ; **FLOATING
C1521 a_35349_62080.n2 VSS 0.12279f ; **FLOATING
C1522 a_35349_62080.t16 VSS 8.30003f ; **FLOATING
C1523 a_35349_62080.t20 VSS 34.0762f ; **FLOATING
C1524 a_35349_62080.t18 VSS 3.74709f ; **FLOATING
C1525 a_35349_62080.n3 VSS 0.65613f ; **FLOATING
C1526 a_35349_62080.t25 VSS 0.0895f ; **FLOATING
C1527 a_35349_62080.t26 VSS 0.0895f ; **FLOATING
C1528 a_35349_62080.n4 VSS 0.11896f ; **FLOATING
C1529 a_35349_62080.n5 VSS 0.43335f ; **FLOATING
C1530 a_35349_62080.n6 VSS 0.24188f ; **FLOATING
C1531 a_35349_62080.n7 VSS 1.01042f ; **FLOATING
C1532 a_35349_62080.n8 VSS 0.17245f ; **FLOATING
C1533 a_35349_62080.n9 VSS 0.08783f ; **FLOATING
C1534 a_35349_62080.n10 VSS 0.16553f ; **FLOATING
C1535 a_35349_62080.t22 VSS 0.18161f ; **FLOATING
C1536 a_35349_62080.t21 VSS 0.26434f ; **FLOATING
C1537 a_35349_62080.n11 VSS 0.12272f ; **FLOATING
C1538 a_35349_62080.t23 VSS 0.18161f ; **FLOATING
C1539 a_35349_62080.t24 VSS 0.26434f ; **FLOATING
C1540 a_35349_62080.n12 VSS 0.12272f ; **FLOATING
C1541 a_35349_62080.n13 VSS 0.20395f ; **FLOATING
C1542 a_35349_62080.n14 VSS 0.23046f ; **FLOATING
C1543 a_35349_62080.n15 VSS 0.17114f ; **FLOATING
C1544 a_35349_62080.n16 VSS 0.19551f ; **FLOATING
C1545 a_35349_62080.t7 VSS 4.46004f ; **FLOATING
C1546 a_35349_62080.t8 VSS 0.25234f ; **FLOATING
C1547 a_1400_1460.t34 VSS 0.14069f ; **FLOATING
C1548 a_1400_1460.t38 VSS 76.2571f ; **FLOATING
C1549 a_1400_1460.t29 VSS 0.02242f ; **FLOATING
C1550 a_1400_1460.t1 VSS 0.11704f ; **FLOATING
C1551 a_1400_1460.t0 VSS 0.08611f ; **FLOATING
C1552 a_1400_1460.t22 VSS 0.03143f ; **FLOATING
C1553 a_1400_1460.t19 VSS 0.03143f ; **FLOATING
C1554 a_1400_1460.t18 VSS 0.06632f ; **FLOATING
C1555 a_1400_1460.t17 VSS 0.04657f ; **FLOATING
C1556 a_1400_1460.n0 VSS 0.21731f ; **FLOATING
C1557 a_1400_1460.t20 VSS 0.04657f ; **FLOATING
C1558 a_1400_1460.n1 VSS 0.11203f ; **FLOATING
C1559 a_1400_1460.t8 VSS 0.14346f ; **FLOATING
C1560 a_1400_1460.t7 VSS 0.08611f ; **FLOATING
C1561 a_1400_1460.n2 VSS 0.26173f ; **FLOATING
C1562 a_1400_1460.n3 VSS 0.15519f ; **FLOATING
C1563 a_1400_1460.n4 VSS 0.09067f ; **FLOATING
C1564 a_1400_1460.t23 VSS 0.04657f ; **FLOATING
C1565 a_1400_1460.n5 VSS 0.21113f ; **FLOATING
C1566 a_1400_1460.n6 VSS 0.09954f ; **FLOATING
C1567 a_1400_1460.t11 VSS 0.10998f ; **FLOATING
C1568 a_1400_1460.t12 VSS 0.08611f ; **FLOATING
C1569 a_1400_1460.t25 VSS 0.04139f ; **FLOATING
C1570 a_1400_1460.t26 VSS 0.09319f ; **FLOATING
C1571 a_1400_1460.n7 VSS 0.19382f ; **FLOATING
C1572 a_1400_1460.n8 VSS 0.1113f ; **FLOATING
C1573 a_1400_1460.n9 VSS 0.26788f ; **FLOATING
C1574 a_1400_1460.t2 VSS 0.09344f ; **FLOATING
C1575 a_1400_1460.n10 VSS 0.23804f ; **FLOATING
C1576 a_1400_1460.t3 VSS 0.09344f ; **FLOATING
C1577 a_1400_1460.n11 VSS 0.23804f ; **FLOATING
C1578 a_1400_1460.t9 VSS 0.09344f ; **FLOATING
C1579 a_1400_1460.n12 VSS 0.23804f ; **FLOATING
C1580 a_1400_1460.t10 VSS 0.09344f ; **FLOATING
C1581 a_1400_1460.n13 VSS 0.23804f ; **FLOATING
C1582 a_1400_1460.t37 VSS 0.09344f ; **FLOATING
C1583 a_1400_1460.n14 VSS 0.23804f ; **FLOATING
C1584 a_1400_1460.t36 VSS 0.09344f ; **FLOATING
C1585 a_1400_1460.n15 VSS 0.15216f ; **FLOATING
C1586 a_1400_1460.t15 VSS 0.0485f ; **FLOATING
C1587 a_1400_1460.n16 VSS 0.15673f ; **FLOATING
C1588 a_1400_1460.t16 VSS 0.0485f ; **FLOATING
C1589 a_1400_1460.n17 VSS 0.15673f ; **FLOATING
C1590 a_1400_1460.t27 VSS 0.0485f ; **FLOATING
C1591 a_1400_1460.n18 VSS 0.15673f ; **FLOATING
C1592 a_1400_1460.t28 VSS 0.0485f ; **FLOATING
C1593 a_1400_1460.n19 VSS 0.11093f ; **FLOATING
C1594 a_1400_1460.n20 VSS 0.1375f ; **FLOATING
C1595 a_1400_1460.n21 VSS 0.15237f ; **FLOATING
C1596 a_1400_1460.n22 VSS 0.24294f ; **FLOATING
C1597 a_1400_1460.n23 VSS 0.18006f ; **FLOATING
C1598 a_1400_1460.t14 VSS 0.02694f ; **FLOATING
C1599 a_1400_1460.n24 VSS 0.23055f ; **FLOATING
C1600 a_1400_1460.t30 VSS 0.03188f ; **FLOATING
C1601 a_1400_1460.n25 VSS 0.23148f ; **FLOATING
C1602 a_1400_1460.t13 VSS 0.02694f ; **FLOATING
C1603 a_1400_1460.n26 VSS 0.2266f ; **FLOATING
C1604 a_1400_1460.t6 VSS 0.03188f ; **FLOATING
C1605 a_1400_1460.n27 VSS 0.23148f ; **FLOATING
C1606 a_1400_1460.t4 VSS 0.02694f ; **FLOATING
C1607 a_1400_1460.n28 VSS 0.2266f ; **FLOATING
C1608 a_1400_1460.t31 VSS 0.03188f ; **FLOATING
C1609 a_1400_1460.n29 VSS 0.23148f ; **FLOATING
C1610 a_1400_1460.t5 VSS 0.02694f ; **FLOATING
C1611 a_1400_1460.n30 VSS 0.16362f ; **FLOATING
C1612 a_1400_1460.t39 VSS 0.08369f ; **FLOATING
C1613 a_1400_1460.t40 VSS 0.07863f ; **FLOATING
C1614 a_1400_1460.n31 VSS 0.07166f ; **FLOATING
C1615 a_1400_1460.t41 VSS 0.07863f ; **FLOATING
C1616 a_1400_1460.n32 VSS 0.03951f ; **FLOATING
C1617 a_1400_1460.t42 VSS 0.07863f ; **FLOATING
C1618 a_1400_1460.n33 VSS 0.03951f ; **FLOATING
C1619 a_1400_1460.t43 VSS 0.07863f ; **FLOATING
C1620 a_1400_1460.n34 VSS 0.03951f ; **FLOATING
C1621 a_1400_1460.t44 VSS 0.07863f ; **FLOATING
C1622 a_1400_1460.n35 VSS 0.03951f ; **FLOATING
C1623 a_1400_1460.t45 VSS 0.07863f ; **FLOATING
C1624 a_1400_1460.n36 VSS 0.03951f ; **FLOATING
C1625 a_1400_1460.t46 VSS 0.07863f ; **FLOATING
C1626 a_1400_1460.n37 VSS 0.03951f ; **FLOATING
C1627 a_1400_1460.t47 VSS 0.07863f ; **FLOATING
C1628 a_1400_1460.n38 VSS 0.03951f ; **FLOATING
C1629 a_1400_1460.t48 VSS 0.07863f ; **FLOATING
C1630 a_1400_1460.n39 VSS 0.03951f ; **FLOATING
C1631 a_1400_1460.t49 VSS 0.07863f ; **FLOATING
C1632 a_1400_1460.n40 VSS 0.03951f ; **FLOATING
C1633 a_1400_1460.t50 VSS 0.07863f ; **FLOATING
C1634 a_1400_1460.n41 VSS 0.03767f ; **FLOATING
C1635 a_1400_1460.t62 VSS 0.08369f ; **FLOATING
C1636 a_1400_1460.t61 VSS 0.07863f ; **FLOATING
C1637 a_1400_1460.n42 VSS 0.07166f ; **FLOATING
C1638 a_1400_1460.t60 VSS 0.07863f ; **FLOATING
C1639 a_1400_1460.n43 VSS 0.03951f ; **FLOATING
C1640 a_1400_1460.t59 VSS 0.07863f ; **FLOATING
C1641 a_1400_1460.n44 VSS 0.03951f ; **FLOATING
C1642 a_1400_1460.t58 VSS 0.07863f ; **FLOATING
C1643 a_1400_1460.n45 VSS 0.03951f ; **FLOATING
C1644 a_1400_1460.t57 VSS 0.07863f ; **FLOATING
C1645 a_1400_1460.n46 VSS 0.03951f ; **FLOATING
C1646 a_1400_1460.t56 VSS 0.07863f ; **FLOATING
C1647 a_1400_1460.n47 VSS 0.03951f ; **FLOATING
C1648 a_1400_1460.t55 VSS 0.07863f ; **FLOATING
C1649 a_1400_1460.n48 VSS 0.03951f ; **FLOATING
C1650 a_1400_1460.t54 VSS 0.07863f ; **FLOATING
C1651 a_1400_1460.n49 VSS 0.03951f ; **FLOATING
C1652 a_1400_1460.t53 VSS 0.07863f ; **FLOATING
C1653 a_1400_1460.n50 VSS 0.03951f ; **FLOATING
C1654 a_1400_1460.t52 VSS 0.07863f ; **FLOATING
C1655 a_1400_1460.n51 VSS 0.03951f ; **FLOATING
C1656 a_1400_1460.t51 VSS 0.07863f ; **FLOATING
C1657 a_1400_1460.n52 VSS 0.03767f ; **FLOATING
C1658 a_1400_1460.n53 VSS 0.44306f ; **FLOATING
C1659 a_1400_1460.t63 VSS 0.08477f ; **FLOATING
C1660 a_1400_1460.t64 VSS 0.07973f ; **FLOATING
C1661 a_1400_1460.n54 VSS 0.0739f ; **FLOATING
C1662 a_1400_1460.t65 VSS 0.07973f ; **FLOATING
C1663 a_1400_1460.n55 VSS 0.04061f ; **FLOATING
C1664 a_1400_1460.t66 VSS 0.07973f ; **FLOATING
C1665 a_1400_1460.n56 VSS 0.04061f ; **FLOATING
C1666 a_1400_1460.t67 VSS 0.07973f ; **FLOATING
C1667 a_1400_1460.n57 VSS 0.04061f ; **FLOATING
C1668 a_1400_1460.t68 VSS 0.07973f ; **FLOATING
C1669 a_1400_1460.n58 VSS 0.04061f ; **FLOATING
C1670 a_1400_1460.t69 VSS 0.07973f ; **FLOATING
C1671 a_1400_1460.n59 VSS 0.04061f ; **FLOATING
C1672 a_1400_1460.t70 VSS 0.07973f ; **FLOATING
C1673 a_1400_1460.n60 VSS 0.04061f ; **FLOATING
C1674 a_1400_1460.t71 VSS 0.07973f ; **FLOATING
C1675 a_1400_1460.n61 VSS 0.04061f ; **FLOATING
C1676 a_1400_1460.t72 VSS 0.07973f ; **FLOATING
C1677 a_1400_1460.n62 VSS 0.04061f ; **FLOATING
C1678 a_1400_1460.t73 VSS 0.07973f ; **FLOATING
C1679 a_1400_1460.n63 VSS 0.04061f ; **FLOATING
C1680 a_1400_1460.t74 VSS 0.07973f ; **FLOATING
C1681 a_1400_1460.n64 VSS 0.03877f ; **FLOATING
C1682 a_1400_1460.t86 VSS 0.08477f ; **FLOATING
C1683 a_1400_1460.t85 VSS 0.07973f ; **FLOATING
C1684 a_1400_1460.n65 VSS 0.0739f ; **FLOATING
C1685 a_1400_1460.t84 VSS 0.07973f ; **FLOATING
C1686 a_1400_1460.n66 VSS 0.04061f ; **FLOATING
C1687 a_1400_1460.t83 VSS 0.07973f ; **FLOATING
C1688 a_1400_1460.n67 VSS 0.04061f ; **FLOATING
C1689 a_1400_1460.t82 VSS 0.07973f ; **FLOATING
C1690 a_1400_1460.n68 VSS 0.04061f ; **FLOATING
C1691 a_1400_1460.t81 VSS 0.07973f ; **FLOATING
C1692 a_1400_1460.n69 VSS 0.04061f ; **FLOATING
C1693 a_1400_1460.t80 VSS 0.07973f ; **FLOATING
C1694 a_1400_1460.n70 VSS 0.04061f ; **FLOATING
C1695 a_1400_1460.t79 VSS 0.07973f ; **FLOATING
C1696 a_1400_1460.n71 VSS 0.04061f ; **FLOATING
C1697 a_1400_1460.t78 VSS 0.07973f ; **FLOATING
C1698 a_1400_1460.n72 VSS 0.04061f ; **FLOATING
C1699 a_1400_1460.t77 VSS 0.07973f ; **FLOATING
C1700 a_1400_1460.n73 VSS 0.04061f ; **FLOATING
C1701 a_1400_1460.t76 VSS 0.07973f ; **FLOATING
C1702 a_1400_1460.n74 VSS 0.04061f ; **FLOATING
C1703 a_1400_1460.t75 VSS 0.07973f ; **FLOATING
C1704 a_1400_1460.n75 VSS 0.03877f ; **FLOATING
C1705 a_1400_1460.n76 VSS 0.54269f ; **FLOATING
C1706 a_1400_1460.n77 VSS 0.23247f ; **FLOATING
C1707 a_1400_1460.t24 VSS 0.02242f ; **FLOATING
C1708 a_1400_1460.n78 VSS 0.07893f ; **FLOATING
C1709 a_1400_1460.t21 VSS 0.03188f ; **FLOATING
C1710 a_1400_1460.n79 VSS 0.11053f ; **FLOATING
C1711 a_1400_1460.n80 VSS 0.9215f ; **FLOATING
C1712 a_1400_1460.n81 VSS 1.17739f ; **FLOATING
C1713 a_1400_1460.t35 VSS 0.08121f ; **FLOATING
C1714 a_1400_1460.t33 VSS 0.08121f ; **FLOATING
C1715 a_1400_1460.n82 VSS 0.09945f ; **FLOATING
C1716 a_1400_1460.n83 VSS 0.26562f ; **FLOATING
C1717 a_1400_1460.t32 VSS 0.31978f ; **FLOATING
C1718 a_26880_10659.n0 VSS 5.43219f ; **FLOATING
C1719 a_26880_10659.t6 VSS 0.49288f ; **FLOATING
C1720 a_26880_10659.t5 VSS 0.49288f ; **FLOATING
C1721 a_26880_10659.t4 VSS 0.49288f ; **FLOATING
C1722 a_26880_10659.t3 VSS 0.49288f ; **FLOATING
C1723 a_26880_10659.t2 VSS 0.49288f ; **FLOATING
C1724 a_26880_10659.t1 VSS 0.49288f ; **FLOATING
C1725 a_26880_10659.t0 VSS 0.49288f ; **FLOATING
C1726 a_26880_10659.t24 VSS 1.1849f ; **FLOATING
C1727 a_26880_10659.t12 VSS 1.18723f ; **FLOATING
C1728 a_26880_10659.t11 VSS 0.80514f ; **FLOATING
C1729 a_26880_10659.t10 VSS 0.80514f ; **FLOATING
C1730 a_26880_10659.t9 VSS 0.8133f ; **FLOATING
C1731 a_26880_10659.t16 VSS 1.18723f ; **FLOATING
C1732 a_26880_10659.t15 VSS 0.80514f ; **FLOATING
C1733 a_26880_10659.t14 VSS 0.80514f ; **FLOATING
C1734 a_26880_10659.t13 VSS 0.8133f ; **FLOATING
C1735 a_26880_10659.t20 VSS 1.18723f ; **FLOATING
C1736 a_26880_10659.t19 VSS 0.80514f ; **FLOATING
C1737 a_26880_10659.t18 VSS 0.80514f ; **FLOATING
C1738 a_26880_10659.t17 VSS 0.8133f ; **FLOATING
C1739 a_26880_10659.t21 VSS 0.81262f ; **FLOATING
C1740 a_26880_10659.n1 VSS 2.42636f ; **FLOATING
C1741 a_26880_10659.n2 VSS 1.98557f ; **FLOATING
C1742 a_26880_10659.n3 VSS 0.89786f ; **FLOATING
C1743 a_26880_10659.n4 VSS 2.42636f ; **FLOATING
C1744 a_26880_10659.n5 VSS 1.98557f ; **FLOATING
C1745 a_26880_10659.n6 VSS 0.81472f ; **FLOATING
C1746 a_26880_10659.n7 VSS 0.53159f ; **FLOATING
C1747 a_26880_10659.n8 VSS 2.42636f ; **FLOATING
C1748 a_26880_10659.n9 VSS 1.98557f ; **FLOATING
C1749 a_26880_10659.n10 VSS 0.81472f ; **FLOATING
C1750 a_26880_10659.n11 VSS 0.40329f ; **FLOATING
C1751 a_26880_10659.t7 VSS 0.40699f ; **FLOATING
C1752 a_26880_10659.t8 VSS 0.41277f ; **FLOATING
C1753 a_26880_10659.n12 VSS 3.67502f ; **FLOATING
C1754 a_26880_10659.n13 VSS 0.8154f ; **FLOATING
C1755 a_26880_10659.t22 VSS 2.79071f ; **FLOATING
C1756 a_26880_10659.t23 VSS 3.23383f ; **FLOATING
C1757 a_31080_10659.n0 VSS 6.01742f ; **FLOATING
C1758 a_31080_10659.t22 VSS 0.58819f ; **FLOATING
C1759 a_31080_10659.t21 VSS 0.58819f ; **FLOATING
C1760 a_31080_10659.t20 VSS 0.58819f ; **FLOATING
C1761 a_31080_10659.t19 VSS 0.58819f ; **FLOATING
C1762 a_31080_10659.t18 VSS 0.58819f ; **FLOATING
C1763 a_31080_10659.t17 VSS 0.58819f ; **FLOATING
C1764 a_31080_10659.t16 VSS 0.58819f ; **FLOATING
C1765 a_31080_10659.t15 VSS 1.42798f ; **FLOATING
C1766 a_31080_10659.t3 VSS 1.43105f ; **FLOATING
C1767 a_31080_10659.t2 VSS 0.96572f ; **FLOATING
C1768 a_31080_10659.t1 VSS 0.96572f ; **FLOATING
C1769 a_31080_10659.t0 VSS 0.96735f ; **FLOATING
C1770 a_31080_10659.t7 VSS 1.43105f ; **FLOATING
C1771 a_31080_10659.t6 VSS 0.96572f ; **FLOATING
C1772 a_31080_10659.t5 VSS 0.96572f ; **FLOATING
C1773 a_31080_10659.t4 VSS 0.96735f ; **FLOATING
C1774 a_31080_10659.t11 VSS 1.43105f ; **FLOATING
C1775 a_31080_10659.t10 VSS 0.96572f ; **FLOATING
C1776 a_31080_10659.t9 VSS 0.96572f ; **FLOATING
C1777 a_31080_10659.t8 VSS 0.96735f ; **FLOATING
C1778 a_31080_10659.t12 VSS 0.96619f ; **FLOATING
C1779 a_31080_10659.n1 VSS 2.53211f ; **FLOATING
C1780 a_31080_10659.n2 VSS 2.0734f ; **FLOATING
C1781 a_31080_10659.n3 VSS 1.02163f ; **FLOATING
C1782 a_31080_10659.n4 VSS 2.53211f ; **FLOATING
C1783 a_31080_10659.n5 VSS 2.0734f ; **FLOATING
C1784 a_31080_10659.n6 VSS 0.92241f ; **FLOATING
C1785 a_31080_10659.n7 VSS 0.63439f ; **FLOATING
C1786 a_31080_10659.n8 VSS 2.53211f ; **FLOATING
C1787 a_31080_10659.n9 VSS 2.0734f ; **FLOATING
C1788 a_31080_10659.n10 VSS 0.92241f ; **FLOATING
C1789 a_31080_10659.n11 VSS 0.48127f ; **FLOATING
C1790 a_31080_10659.t23 VSS 0.48569f ; **FLOATING
C1791 a_31080_10659.t24 VSS 0.4926f ; **FLOATING
C1792 a_31080_10659.n12 VSS 4.03432f ; **FLOATING
C1793 a_31080_10659.n13 VSS 0.92357f ; **FLOATING
C1794 a_31080_10659.t13 VSS 3.03912f ; **FLOATING
C1795 a_31080_10659.t14 VSS 3.50089f ; **FLOATING
C1796 a_35280_10659.t1 VSS 0.61542f ; **FLOATING
C1797 a_35280_10659.t5 VSS 1.50994f ; **FLOATING
C1798 a_35280_10659.t4 VSS 1.01583f ; **FLOATING
C1799 a_35280_10659.t3 VSS 1.01583f ; **FLOATING
C1800 a_35280_10659.t2 VSS 1.01694f ; **FLOATING
C1801 a_35280_10659.t9 VSS 1.50994f ; **FLOATING
C1802 a_35280_10659.t8 VSS 1.01583f ; **FLOATING
C1803 a_35280_10659.t7 VSS 1.01583f ; **FLOATING
C1804 a_35280_10659.t6 VSS 1.01694f ; **FLOATING
C1805 a_35280_10659.t13 VSS 1.50994f ; **FLOATING
C1806 a_35280_10659.t12 VSS 1.01583f ; **FLOATING
C1807 a_35280_10659.t11 VSS 1.01583f ; **FLOATING
C1808 a_35280_10659.t10 VSS 1.01694f ; **FLOATING
C1809 a_35280_10659.t17 VSS 1.50915f ; **FLOATING
C1810 a_35280_10659.t16 VSS 1.01547f ; **FLOATING
C1811 a_35280_10659.t15 VSS 1.01547f ; **FLOATING
C1812 a_35280_10659.t14 VSS 1.01658f ; **FLOATING
C1813 a_35280_10659.t0 VSS 10.9431f ; **FLOATING
C1814 a_35280_10659.n0 VSS 2.27104f ; **FLOATING
C1815 a_35280_10659.n1 VSS 1.80942f ; **FLOATING
C1816 a_35280_10659.n2 VSS 1.05843f ; **FLOATING
C1817 a_35280_10659.n3 VSS 2.27104f ; **FLOATING
C1818 a_35280_10659.n4 VSS 1.80942f ; **FLOATING
C1819 a_35280_10659.n5 VSS 0.95462f ; **FLOATING
C1820 a_35280_10659.n6 VSS 0.66376f ; **FLOATING
C1821 a_35280_10659.n7 VSS 2.27104f ; **FLOATING
C1822 a_35280_10659.n8 VSS 1.80942f ; **FLOATING
C1823 a_35280_10659.n9 VSS 0.95462f ; **FLOATING
C1824 a_35280_10659.n10 VSS 0.50356f ; **FLOATING
C1825 a_35280_10659.n11 VSS 2.27219f ; **FLOATING
C1826 a_35280_10659.n12 VSS 1.80978f ; **FLOATING
C1827 a_35280_10659.n13 VSS 0.95497f ; **FLOATING
C1828 a_35280_10659.n14 VSS 3.50692f ; **FLOATING
C1829 a_39480_10659.n0 VSS 5.74789f ; **FLOATING
C1830 a_39480_10659.t22 VSS 0.60401f ; **FLOATING
C1831 a_39480_10659.t21 VSS 0.60401f ; **FLOATING
C1832 a_39480_10659.t20 VSS 0.60401f ; **FLOATING
C1833 a_39480_10659.t24 VSS 0.60401f ; **FLOATING
C1834 a_39480_10659.t19 VSS 0.60401f ; **FLOATING
C1835 a_39480_10659.t18 VSS 0.60401f ; **FLOATING
C1836 a_39480_10659.t17 VSS 0.60401f ; **FLOATING
C1837 a_39480_10659.t15 VSS 1.47076f ; **FLOATING
C1838 a_39480_10659.t3 VSS 1.46759f ; **FLOATING
C1839 a_39480_10659.t2 VSS 0.99094f ; **FLOATING
C1840 a_39480_10659.t1 VSS 0.99094f ; **FLOATING
C1841 a_39480_10659.t0 VSS 0.99164f ; **FLOATING
C1842 a_39480_10659.t7 VSS 1.46759f ; **FLOATING
C1843 a_39480_10659.t6 VSS 0.99094f ; **FLOATING
C1844 a_39480_10659.t5 VSS 0.99094f ; **FLOATING
C1845 a_39480_10659.t4 VSS 0.99164f ; **FLOATING
C1846 a_39480_10659.t11 VSS 1.46759f ; **FLOATING
C1847 a_39480_10659.t10 VSS 0.99094f ; **FLOATING
C1848 a_39480_10659.t9 VSS 0.99094f ; **FLOATING
C1849 a_39480_10659.t8 VSS 0.99164f ; **FLOATING
C1850 a_39480_10659.n1 VSS 1.89575f ; **FLOATING
C1851 a_39480_10659.n2 VSS 1.43393f ; **FLOATING
C1852 a_39480_10659.n3 VSS 1.03967f ; **FLOATING
C1853 a_39480_10659.n4 VSS 1.89575f ; **FLOATING
C1854 a_39480_10659.n5 VSS 1.43393f ; **FLOATING
C1855 a_39480_10659.n6 VSS 0.93778f ; **FLOATING
C1856 a_39480_10659.n7 VSS 0.65145f ; **FLOATING
C1857 a_39480_10659.n8 VSS 1.89575f ; **FLOATING
C1858 a_39480_10659.n9 VSS 1.43393f ; **FLOATING
C1859 a_39480_10659.n10 VSS 0.93778f ; **FLOATING
C1860 a_39480_10659.n11 VSS 0.49422f ; **FLOATING
C1861 a_39480_10659.t23 VSS 0.49876f ; **FLOATING
C1862 a_39480_10659.t16 VSS 0.50585f ; **FLOATING
C1863 a_39480_10659.n12 VSS 3.03688f ; **FLOATING
C1864 a_39480_10659.t12 VSS 1.92941f ; **FLOATING
C1865 a_39480_10659.t13 VSS 2.42486f ; **FLOATING
C1866 a_39480_10659.t14 VSS 2.88352f ; **FLOATING
C1867 a_43680_10659.t5 VSS 1.21134f ; **FLOATING
C1868 a_43680_10659.t4 VSS 0.82207f ; **FLOATING
C1869 a_43680_10659.t3 VSS 0.82207f ; **FLOATING
C1870 a_43680_10659.t2 VSS 0.82419f ; **FLOATING
C1871 a_43680_10659.t9 VSS 1.21134f ; **FLOATING
C1872 a_43680_10659.t8 VSS 0.82207f ; **FLOATING
C1873 a_43680_10659.t7 VSS 0.82207f ; **FLOATING
C1874 a_43680_10659.t6 VSS 0.82419f ; **FLOATING
C1875 a_43680_10659.t13 VSS 1.21134f ; **FLOATING
C1876 a_43680_10659.t12 VSS 0.82207f ; **FLOATING
C1877 a_43680_10659.t11 VSS 0.82207f ; **FLOATING
C1878 a_43680_10659.t10 VSS 0.82419f ; **FLOATING
C1879 a_43680_10659.t17 VSS 1.21373f ; **FLOATING
C1880 a_43680_10659.t16 VSS 0.82277f ; **FLOATING
C1881 a_43680_10659.t15 VSS 0.82277f ; **FLOATING
C1882 a_43680_10659.t14 VSS 0.82489f ; **FLOATING
C1883 a_43680_10659.n0 VSS 1.30155f ; **FLOATING
C1884 a_43680_10659.n1 VSS 0.88881f ; **FLOATING
C1885 a_43680_10659.n2 VSS 0.88482f ; **FLOATING
C1886 a_43680_10659.n3 VSS 1.30155f ; **FLOATING
C1887 a_43680_10659.n4 VSS 0.88881f ; **FLOATING
C1888 a_43680_10659.n5 VSS 0.79989f ; **FLOATING
C1889 a_43680_10659.n6 VSS 0.54305f ; **FLOATING
C1890 a_43680_10659.n7 VSS 1.30155f ; **FLOATING
C1891 a_43680_10659.n8 VSS 0.88881f ; **FLOATING
C1892 a_43680_10659.n9 VSS 0.79989f ; **FLOATING
C1893 a_43680_10659.n10 VSS 0.41198f ; **FLOATING
C1894 a_43680_10659.n11 VSS 1.29846f ; **FLOATING
C1895 a_43680_10659.n12 VSS 0.88811f ; **FLOATING
C1896 a_43680_10659.n13 VSS 0.79919f ; **FLOATING
C1897 a_43680_10659.n14 VSS 2.16391f ; **FLOATING
C1898 a_43680_10659.t0 VSS 8.49361f ; **FLOATING
C1899 a_43680_10659.t1 VSS 0.41576f ; **FLOATING
C1900 a_1601_15740.n0 VSS 0.92416f ; **FLOATING
C1901 a_1601_15740.n1 VSS 2.49289f ; **FLOATING
C1902 a_1601_15740.t14 VSS 0.39019f ; **FLOATING
C1903 a_1601_15740.t12 VSS 0.37132f ; **FLOATING
C1904 a_1601_15740.t11 VSS 0.37132f ; **FLOATING
C1905 a_1601_15740.t13 VSS 0.37465f ; **FLOATING
C1906 a_1601_15740.t9 VSS 0.51926f ; **FLOATING
C1907 a_1601_15740.t5 VSS 0.47943f ; **FLOATING
C1908 a_1601_15740.t0 VSS 0.45256f ; **FLOATING
C1909 a_1601_15740.t1 VSS 0.58591f ; **FLOATING
C1910 a_1601_15740.t2 VSS 2.66681f ; **FLOATING
C1911 a_1601_15740.t3 VSS 27.6925f ; **FLOATING
C1912 a_1601_15740.n2 VSS 4.3107f ; **FLOATING
C1913 a_1601_15740.n3 VSS 2.63474f ; **FLOATING
C1914 a_1601_15740.t6 VSS 3.22093f ; **FLOATING
C1915 a_1601_15740.t7 VSS 1.23999f ; **FLOATING
C1916 a_2037_15740.n0 VSS 0.73782f ; **FLOATING
C1917 a_2037_15740.n1 VSS 2.64784f ; **FLOATING
C1918 a_2037_15740.t14 VSS 0.36051f ; **FLOATING
C1919 a_2037_15740.t12 VSS 0.34364f ; **FLOATING
C1920 a_2037_15740.t11 VSS 0.34364f ; **FLOATING
C1921 a_2037_15740.t13 VSS 0.34393f ; **FLOATING
C1922 a_2037_15740.t9 VSS 0.42635f ; **FLOATING
C1923 a_2037_15740.t5 VSS 0.4384f ; **FLOATING
C1924 a_2037_15740.t1 VSS 0.42291f ; **FLOATING
C1925 a_2037_15740.t4 VSS 0.49781f ; **FLOATING
C1926 a_2037_15740.t0 VSS 2.3475f ; **FLOATING
C1927 a_2037_15740.t2 VSS 25.7766f ; **FLOATING
C1928 a_2037_15740.n2 VSS 4.07318f ; **FLOATING
C1929 a_2037_15740.n3 VSS 1.61743f ; **FLOATING
C1930 a_2037_15740.t6 VSS 2.54001f ; **FLOATING
C1931 a_2037_15740.t7 VSS 0.73391f ; **FLOATING
C1932 a_1545_5800.t1 VSS 0.25661f ; **FLOATING
C1933 a_1545_5800.t3 VSS 0.77165f ; **FLOATING
C1934 a_1545_5800.t4 VSS 0.44102f ; **FLOATING
C1935 a_1545_5800.t5 VSS 0.415f ; **FLOATING
C1936 a_1545_5800.n0 VSS 0.45609f ; **FLOATING
C1937 a_1545_5800.t7 VSS 0.44102f ; **FLOATING
C1938 a_1545_5800.t6 VSS 0.415f ; **FLOATING
C1939 a_1545_5800.n1 VSS 0.45609f ; **FLOATING
C1940 a_1545_5800.n2 VSS 1.74392f ; **FLOATING
C1941 a_1545_5800.n3 VSS 3.77354f ; **FLOATING
C1942 a_1545_5800.t2 VSS 0.21684f ; **FLOATING
C1943 a_1545_5800.n4 VSS 2.07678f ; **FLOATING
C1944 a_1545_5800.n5 VSS 6.34937f ; **FLOATING
C1945 a_1545_5800.t0 VSS 5.5555f ; **FLOATING
C1946 a_3225_5800.t4 VSS 0.49566f ; **FLOATING
C1947 a_3225_5800.t5 VSS 0.46604f ; **FLOATING
C1948 a_3225_5800.n0 VSS 0.41865f ; **FLOATING
C1949 a_3225_5800.t7 VSS 0.49566f ; **FLOATING
C1950 a_3225_5800.t6 VSS 0.46604f ; **FLOATING
C1951 a_3225_5800.n1 VSS 0.41865f ; **FLOATING
C1952 a_3225_5800.n2 VSS 2.56567f ; **FLOATING
C1953 a_3225_5800.t3 VSS 0.27738f ; **FLOATING
C1954 a_3225_5800.n3 VSS 3.16502f ; **FLOATING
C1955 a_3225_5800.t1 VSS 0.27433f ; **FLOATING
C1956 a_3225_5800.n4 VSS 6.88141f ; **FLOATING
C1957 a_3225_5800.t2 VSS 7.11074f ; **FLOATING
C1958 a_3225_5800.t0 VSS 0.38458f ; **FLOATING
C1959 a_1601_10659.n0 VSS 1.86186f ; **FLOATING
C1960 a_1601_10659.t16 VSS 2.7598f ; **FLOATING
C1961 a_1601_10659.t15 VSS 0.39479f ; **FLOATING
C1962 a_1601_10659.t6 VSS 0.52539f ; **FLOATING
C1963 a_1601_10659.t3 VSS 0.45947f ; **FLOATING
C1964 a_1601_10659.t13 VSS 0.49322f ; **FLOATING
C1965 a_1601_10659.t12 VSS 0.45926f ; **FLOATING
C1966 a_1601_10659.t11 VSS 0.45926f ; **FLOATING
C1967 a_1601_10659.t10 VSS 0.46153f ; **FLOATING
C1968 a_1601_10659.t1 VSS 0.45943f ; **FLOATING
C1969 a_1601_10659.t0 VSS 0.52575f ; **FLOATING
C1970 a_1601_10659.n1 VSS 3.56583f ; **FLOATING
C1971 a_1601_10659.t17 VSS 0.23801f ; **FLOATING
C1972 a_1601_10659.t7 VSS 0.32067f ; **FLOATING
C1973 a_1601_10659.t5 VSS 0.30174f ; **FLOATING
C1974 a_1601_10659.n2 VSS 0.33162f ; **FLOATING
C1975 a_1601_10659.t2 VSS 0.32067f ; **FLOATING
C1976 a_1601_10659.t4 VSS 0.30174f ; **FLOATING
C1977 a_1601_10659.n3 VSS 0.33162f ; **FLOATING
C1978 a_1601_10659.n4 VSS 0.72595f ; **FLOATING
C1979 a_1601_10659.n5 VSS 0.7793f ; **FLOATING
C1980 a_1601_10659.n6 VSS 1.21494f ; **FLOATING
C1981 a_1601_10659.n7 VSS 1.40297f ; **FLOATING
C1982 a_1601_10659.t8 VSS 0.20115f ; **FLOATING
C1983 a_1601_10659.n8 VSS 3.01783f ; **FLOATING
C1984 a_1601_10659.t18 VSS 28.5915f ; **FLOATING
C1985 a_1601_10659.n9 VSS 2.14527f ; **FLOATING
C1986 a_1601_10659.t9 VSS 0.35785f ; **FLOATING
C1987 a_1601_10659.n10 VSS 1.09884f ; **FLOATING
C1988 a_1601_10659.t14 VSS 0.36076f ; **FLOATING
C1989 a_1601_10659.n11 VSS 1.39304f ; **FLOATING
C1990 a_1601_10659.n12 VSS 2.97405f ; **FLOATING
C1991 a_2037_10659.n0 VSS 3.39039f ; **FLOATING
C1992 a_2037_10659.n1 VSS 4.83691f ; **FLOATING
C1993 a_2037_10659.t15 VSS 0.43457f ; **FLOATING
C1994 a_2037_10659.t16 VSS 2.89601f ; **FLOATING
C1995 a_2037_10659.t4 VSS 0.51394f ; **FLOATING
C1996 a_2037_10659.t1 VSS 0.50361f ; **FLOATING
C1997 a_2037_10659.t8 VSS 0.50353f ; **FLOATING
C1998 a_2037_10659.t7 VSS 0.51435f ; **FLOATING
C1999 a_2037_10659.t13 VSS 0.51666f ; **FLOATING
C2000 a_2037_10659.t12 VSS 0.50353f ; **FLOATING
C2001 a_2037_10659.t11 VSS 0.50353f ; **FLOATING
C2002 a_2037_10659.t10 VSS 0.50361f ; **FLOATING
C2003 a_2037_10659.t5 VSS 0.3516f ; **FLOATING
C2004 a_2037_10659.t3 VSS 0.33059f ; **FLOATING
C2005 a_2037_10659.n2 VSS 0.29697f ; **FLOATING
C2006 a_2037_10659.t0 VSS 0.3516f ; **FLOATING
C2007 a_2037_10659.t2 VSS 0.33059f ; **FLOATING
C2008 a_2037_10659.n3 VSS 0.29697f ; **FLOATING
C2009 a_2037_10659.n4 VSS 0.11071f ; **FLOATING
C2010 a_2037_10659.n5 VSS 0.47448f ; **FLOATING
C2011 a_2037_10659.n6 VSS 1.14984f ; **FLOATING
C2012 a_2037_10659.t6 VSS 0.17551f ; **FLOATING
C2013 a_2037_10659.n7 VSS 3.83249f ; **FLOATING
C2014 a_2037_10659.t17 VSS 31.6976f ; **FLOATING
C2015 a_2037_10659.n8 VSS 0.40639f ; **FLOATING
C2016 a_2037_10659.t19 VSS 0.6941f ; **FLOATING
C2017 a_2037_10659.n9 VSS 4.83063f ; **FLOATING
C2018 a_2037_10659.t9 VSS 0.4029f ; **FLOATING
C2019 a_2037_10659.n10 VSS 1.52877f ; **FLOATING
C2020 a_2037_10659.t14 VSS 0.39943f ; **FLOATING
C2021 a_1469_11989.t3 VSS 0.57182f ; **FLOATING
C2022 a_1469_11989.t0 VSS 8.09323f ; **FLOATING
C2023 a_1469_11989.t4 VSS 19.9847f ; **FLOATING
C2024 a_1469_11989.t2 VSS 1.34292f ; **FLOATING
C2025 a_1469_11989.t1 VSS 0.58294f ; **FLOATING
C2026 a_11549_11989.t3 VSS 0.32096f ; **FLOATING
C2027 a_11549_11989.t4 VSS 0.30202f ; **FLOATING
C2028 a_11549_11989.n0 VSS 0.33887f ; **FLOATING
C2029 a_11549_11989.t5 VSS 0.30202f ; **FLOATING
C2030 a_11549_11989.n1 VSS 0.21176f ; **FLOATING
C2031 a_11549_11989.t6 VSS 0.30202f ; **FLOATING
C2032 a_11549_11989.n2 VSS 0.20482f ; **FLOATING
C2033 a_11549_11989.t10 VSS 0.32096f ; **FLOATING
C2034 a_11549_11989.t9 VSS 0.30202f ; **FLOATING
C2035 a_11549_11989.n3 VSS 0.33887f ; **FLOATING
C2036 a_11549_11989.t8 VSS 0.30202f ; **FLOATING
C2037 a_11549_11989.n4 VSS 0.21176f ; **FLOATING
C2038 a_11549_11989.t7 VSS 0.30202f ; **FLOATING
C2039 a_11549_11989.n5 VSS 0.20482f ; **FLOATING
C2040 a_11549_11989.n6 VSS 4.00452f ; **FLOATING
C2041 a_11549_11989.t1 VSS 5.23369f ; **FLOATING
C2042 a_11549_11989.t2 VSS 1.91114f ; **FLOATING
C2043 a_11549_11989.t0 VSS 0.4698f ; **FLOATING
C2044 a_11985_10449.t3 VSS 0.33866f ; **FLOATING
C2045 a_11985_10449.t4 VSS 0.31842f ; **FLOATING
C2046 a_11985_10449.n0 VSS 0.35425f ; **FLOATING
C2047 a_11985_10449.t5 VSS 0.31842f ; **FLOATING
C2048 a_11985_10449.n1 VSS 0.22225f ; **FLOATING
C2049 a_11985_10449.t6 VSS 0.31842f ; **FLOATING
C2050 a_11985_10449.n2 VSS 0.15405f ; **FLOATING
C2051 a_11985_10449.t10 VSS 0.33866f ; **FLOATING
C2052 a_11985_10449.t9 VSS 0.31842f ; **FLOATING
C2053 a_11985_10449.n3 VSS 0.35425f ; **FLOATING
C2054 a_11985_10449.t8 VSS 0.31842f ; **FLOATING
C2055 a_11985_10449.n4 VSS 0.22225f ; **FLOATING
C2056 a_11985_10449.t7 VSS 0.31842f ; **FLOATING
C2057 a_11985_10449.n5 VSS 0.15405f ; **FLOATING
C2058 a_11985_10449.n6 VSS 3.63708f ; **FLOATING
C2059 a_11985_10449.t0 VSS 6.20704f ; **FLOATING
C2060 a_11985_10449.t2 VSS 1.68335f ; **FLOATING
C2061 a_11985_10449.t1 VSS 0.48337f ; **FLOATING
C2062 a_10785_5800.t4 VSS 0.70261f ; **FLOATING
C2063 a_10785_5800.t5 VSS 0.66115f ; **FLOATING
C2064 a_10785_5800.n0 VSS 0.74181f ; **FLOATING
C2065 a_10785_5800.t6 VSS 0.66115f ; **FLOATING
C2066 a_10785_5800.n1 VSS 0.46357f ; **FLOATING
C2067 a_10785_5800.t7 VSS 0.66115f ; **FLOATING
C2068 a_10785_5800.n2 VSS 0.44838f ; **FLOATING
C2069 a_10785_5800.t11 VSS 0.70261f ; **FLOATING
C2070 a_10785_5800.t10 VSS 0.66115f ; **FLOATING
C2071 a_10785_5800.n3 VSS 0.74181f ; **FLOATING
C2072 a_10785_5800.t9 VSS 0.66115f ; **FLOATING
C2073 a_10785_5800.n4 VSS 0.46357f ; **FLOATING
C2074 a_10785_5800.t8 VSS 0.66115f ; **FLOATING
C2075 a_10785_5800.n5 VSS 0.44838f ; **FLOATING
C2076 a_10785_5800.n6 VSS 3.0723f ; **FLOATING
C2077 a_10785_5800.t0 VSS 0.37691f ; **FLOATING
C2078 a_10785_5800.t3 VSS 0.6746f ; **FLOATING
C2079 a_10785_5800.n7 VSS 8.77247f ; **FLOATING
C2080 a_10785_5800.n8 VSS 10.0404f ; **FLOATING
C2081 a_10785_5800.t2 VSS 3.01559f ; **FLOATING
C2082 a_10785_5800.t1 VSS 0.5284f ; **FLOATING
C2083 a_14145_5800.t1 VSS 0.35201f ; **FLOATING
C2084 a_14145_5800.t3 VSS 0.58575f ; **FLOATING
C2085 a_14145_5800.n0 VSS 8.56751f ; **FLOATING
C2086 a_14145_5800.t4 VSS 19.5641f ; **FLOATING
C2087 a_14145_5800.t2 VSS 1.50007f ; **FLOATING
C2088 a_14145_5800.t0 VSS 0.50516f ; **FLOATING
C2089 a_1427_6669.t5 VSS 0.3575f ; **FLOATING
C2090 a_1427_6669.t4 VSS 0.29359f ; **FLOATING
C2091 a_1427_6669.n0 VSS 9.13809f ; **FLOATING
C2092 a_1427_6669.t3 VSS 0.24197f ; **FLOATING
C2093 a_1427_6669.n1 VSS 10.0575f ; **FLOATING
C2094 a_1427_6669.t2 VSS 4.33287f ; **FLOATING
C2095 a_1427_6669.t1 VSS 4.38629f ; **FLOATING
C2096 a_1427_6669.t0 VSS 0.72212f ; **FLOATING
C2097 a_6869_5800.t2 VSS 0.3128f ; **FLOATING
C2098 a_6869_5800.t3 VSS 0.16507f ; **FLOATING
C2099 a_6869_5800.n0 VSS 8.02985f ; **FLOATING
C2100 a_6869_5800.t4 VSS 7.12616f ; **FLOATING
C2101 a_6869_5800.t5 VSS 1.84584f ; **FLOATING
C2102 a_6869_5800.t1 VSS 1.38783f ; **FLOATING
C2103 a_6869_5800.t0 VSS 0.64695f ; **FLOATING
C2104 a_17789_5800.t2 VSS 0.4065f ; **FLOATING
C2105 a_17789_5800.t3 VSS 0.2223f ; **FLOATING
C2106 a_17789_5800.n0 VSS 9.92592f ; **FLOATING
C2107 a_17789_5800.t4 VSS 8.90971f ; **FLOATING
C2108 a_17789_5800.t5 VSS 2.51749f ; **FLOATING
C2109 a_17789_5800.t1 VSS 1.83729f ; **FLOATING
C2110 a_17789_5800.t0 VSS 0.87125f ; **FLOATING
C2111 a_3107_2049.t3 VSS 3.22774f ; **FLOATING
C2112 a_3107_2049.t4 VSS 10.1141f ; **FLOATING
C2113 a_3107_2049.t5 VSS 2.44024f ; **FLOATING
C2114 a_3107_2049.t1 VSS 1.55662f ; **FLOATING
C2115 a_3107_2049.t2 VSS 10.8332f ; **FLOATING
C2116 a_3107_2049.t0 VSS 0.83423f ; **FLOATING
C2117 VTN.t47 VSS 0.34873f ; **FLOATING
C2118 VTN.t46 VSS 0.34873f ; **FLOATING
C2119 VTN.t45 VSS 0.34873f ; **FLOATING
C2120 VTN.t44 VSS 0.34873f ; **FLOATING
C2121 VTN.t43 VSS 0.34873f ; **FLOATING
C2122 VTN.t42 VSS 0.34873f ; **FLOATING
C2123 VTN.t41 VSS 0.34873f ; **FLOATING
C2124 VTN.t40 VSS 0.34873f ; **FLOATING
C2125 VTN.t39 VSS 0.34873f ; **FLOATING
C2126 VTN.t38 VSS 0.34873f ; **FLOATING
C2127 VTN.t37 VSS 0.34873f ; **FLOATING
C2128 VTN.t36 VSS 0.34873f ; **FLOATING
C2129 VTN.t35 VSS 0.34873f ; **FLOATING
C2130 VTN.t34 VSS 0.34873f ; **FLOATING
C2131 VTN.t33 VSS 0.34873f ; **FLOATING
C2132 VTN.t32 VSS 0.45237f ; **FLOATING
C2133 VTN.n0 VSS 0.24721f ; **FLOATING
C2134 VTN.n1 VSS 0.17659f ; **FLOATING
C2135 VTN.n2 VSS 0.17659f ; **FLOATING
C2136 VTN.n3 VSS 0.17659f ; **FLOATING
C2137 VTN.n4 VSS 0.17659f ; **FLOATING
C2138 VTN.n5 VSS 0.17659f ; **FLOATING
C2139 VTN.n6 VSS 0.17659f ; **FLOATING
C2140 VTN.n7 VSS 0.17659f ; **FLOATING
C2141 VTN.n8 VSS 0.17659f ; **FLOATING
C2142 VTN.n9 VSS 0.17659f ; **FLOATING
C2143 VTN.n10 VSS 0.17659f ; **FLOATING
C2144 VTN.n11 VSS 0.17659f ; **FLOATING
C2145 VTN.n12 VSS 0.17659f ; **FLOATING
C2146 VTN.n13 VSS 0.17659f ; **FLOATING
C2147 VTN.n14 VSS 0.16408f ; **FLOATING
C2148 VTN.t48 VSS 0.34873f ; **FLOATING
C2149 VTN.t49 VSS 0.34873f ; **FLOATING
C2150 VTN.t50 VSS 0.34873f ; **FLOATING
C2151 VTN.t51 VSS 0.34873f ; **FLOATING
C2152 VTN.t52 VSS 0.34873f ; **FLOATING
C2153 VTN.t53 VSS 0.34873f ; **FLOATING
C2154 VTN.t54 VSS 0.34873f ; **FLOATING
C2155 VTN.t55 VSS 0.34873f ; **FLOATING
C2156 VTN.t56 VSS 0.34873f ; **FLOATING
C2157 VTN.t57 VSS 0.34873f ; **FLOATING
C2158 VTN.t58 VSS 0.34873f ; **FLOATING
C2159 VTN.t59 VSS 0.34873f ; **FLOATING
C2160 VTN.t60 VSS 0.34873f ; **FLOATING
C2161 VTN.t61 VSS 0.34873f ; **FLOATING
C2162 VTN.t62 VSS 0.34873f ; **FLOATING
C2163 VTN.t63 VSS 0.45237f ; **FLOATING
C2164 VTN.n15 VSS 0.24721f ; **FLOATING
C2165 VTN.n16 VSS 0.17659f ; **FLOATING
C2166 VTN.n17 VSS 0.17659f ; **FLOATING
C2167 VTN.n18 VSS 0.17659f ; **FLOATING
C2168 VTN.n19 VSS 0.17659f ; **FLOATING
C2169 VTN.n20 VSS 0.17659f ; **FLOATING
C2170 VTN.n21 VSS 0.17659f ; **FLOATING
C2171 VTN.n22 VSS 0.17659f ; **FLOATING
C2172 VTN.n23 VSS 0.17659f ; **FLOATING
C2173 VTN.n24 VSS 0.17659f ; **FLOATING
C2174 VTN.n25 VSS 0.17659f ; **FLOATING
C2175 VTN.n26 VSS 0.17659f ; **FLOATING
C2176 VTN.n27 VSS 0.17659f ; **FLOATING
C2177 VTN.n28 VSS 0.17659f ; **FLOATING
C2178 VTN.n29 VSS 0.16408f ; **FLOATING
C2179 VTN.n30 VSS 1.80408f ; **FLOATING
C2180 VTN.t15 VSS 0.34873f ; **FLOATING
C2181 VTN.t14 VSS 0.34873f ; **FLOATING
C2182 VTN.t13 VSS 0.34873f ; **FLOATING
C2183 VTN.t12 VSS 0.34873f ; **FLOATING
C2184 VTN.t11 VSS 0.34873f ; **FLOATING
C2185 VTN.t10 VSS 0.34873f ; **FLOATING
C2186 VTN.t9 VSS 0.34873f ; **FLOATING
C2187 VTN.t8 VSS 0.34873f ; **FLOATING
C2188 VTN.t7 VSS 0.34873f ; **FLOATING
C2189 VTN.t6 VSS 0.34873f ; **FLOATING
C2190 VTN.t5 VSS 0.34873f ; **FLOATING
C2191 VTN.t4 VSS 0.34873f ; **FLOATING
C2192 VTN.t3 VSS 0.34873f ; **FLOATING
C2193 VTN.t2 VSS 0.34873f ; **FLOATING
C2194 VTN.t1 VSS 0.34873f ; **FLOATING
C2195 VTN.t0 VSS 0.45237f ; **FLOATING
C2196 VTN.n31 VSS 0.24721f ; **FLOATING
C2197 VTN.n32 VSS 0.17659f ; **FLOATING
C2198 VTN.n33 VSS 0.17659f ; **FLOATING
C2199 VTN.n34 VSS 0.17659f ; **FLOATING
C2200 VTN.n35 VSS 0.17659f ; **FLOATING
C2201 VTN.n36 VSS 0.17659f ; **FLOATING
C2202 VTN.n37 VSS 0.17659f ; **FLOATING
C2203 VTN.n38 VSS 0.17659f ; **FLOATING
C2204 VTN.n39 VSS 0.17659f ; **FLOATING
C2205 VTN.n40 VSS 0.17659f ; **FLOATING
C2206 VTN.n41 VSS 0.17659f ; **FLOATING
C2207 VTN.n42 VSS 0.17659f ; **FLOATING
C2208 VTN.n43 VSS 0.17659f ; **FLOATING
C2209 VTN.n44 VSS 0.17659f ; **FLOATING
C2210 VTN.n45 VSS 0.16408f ; **FLOATING
C2211 VTN.t16 VSS 0.34873f ; **FLOATING
C2212 VTN.t17 VSS 0.34873f ; **FLOATING
C2213 VTN.t18 VSS 0.34873f ; **FLOATING
C2214 VTN.t19 VSS 0.34873f ; **FLOATING
C2215 VTN.t20 VSS 0.34873f ; **FLOATING
C2216 VTN.t21 VSS 0.34873f ; **FLOATING
C2217 VTN.t22 VSS 0.34873f ; **FLOATING
C2218 VTN.t23 VSS 0.34873f ; **FLOATING
C2219 VTN.t24 VSS 0.34873f ; **FLOATING
C2220 VTN.t25 VSS 0.34873f ; **FLOATING
C2221 VTN.t26 VSS 0.34873f ; **FLOATING
C2222 VTN.t27 VSS 0.34873f ; **FLOATING
C2223 VTN.t28 VSS 0.34873f ; **FLOATING
C2224 VTN.t29 VSS 0.34873f ; **FLOATING
C2225 VTN.t30 VSS 0.34873f ; **FLOATING
C2226 VTN.t31 VSS 0.45237f ; **FLOATING
C2227 VTN.n46 VSS 0.24721f ; **FLOATING
C2228 VTN.n47 VSS 0.17659f ; **FLOATING
C2229 VTN.n48 VSS 0.17659f ; **FLOATING
C2230 VTN.n49 VSS 0.17659f ; **FLOATING
C2231 VTN.n50 VSS 0.17659f ; **FLOATING
C2232 VTN.n51 VSS 0.17659f ; **FLOATING
C2233 VTN.n52 VSS 0.17659f ; **FLOATING
C2234 VTN.n53 VSS 0.17659f ; **FLOATING
C2235 VTN.n54 VSS 0.17659f ; **FLOATING
C2236 VTN.n55 VSS 0.17659f ; **FLOATING
C2237 VTN.n56 VSS 0.17659f ; **FLOATING
C2238 VTN.n57 VSS 0.17659f ; **FLOATING
C2239 VTN.n58 VSS 0.17659f ; **FLOATING
C2240 VTN.n59 VSS 0.17659f ; **FLOATING
C2241 VTN.n60 VSS 0.16408f ; **FLOATING
C2242 VTN.n61 VSS 2.38667f ; **FLOATING
C2243 VTN.n62 VSS 1.41467f ; **FLOATING
C2244 NB.t160 VSS 0.30631f ; **FLOATING
C2245 NB.t161 VSS 0.30631f ; **FLOATING
C2246 NB.n0 VSS 0.34867f ; **FLOATING
C2247 NB.t19 VSS 0.25605f ; **FLOATING
C2248 NB.t18 VSS 0.25605f ; **FLOATING
C2249 NB.t17 VSS 0.25605f ; **FLOATING
C2250 NB.t16 VSS 0.25605f ; **FLOATING
C2251 NB.t15 VSS 0.25605f ; **FLOATING
C2252 NB.t14 VSS 0.25605f ; **FLOATING
C2253 NB.t13 VSS 0.25605f ; **FLOATING
C2254 NB.t12 VSS 0.25605f ; **FLOATING
C2255 NB.t11 VSS 0.25605f ; **FLOATING
C2256 NB.t10 VSS 0.25605f ; **FLOATING
C2257 NB.t9 VSS 0.25605f ; **FLOATING
C2258 NB.t8 VSS 0.25605f ; **FLOATING
C2259 NB.t7 VSS 0.25605f ; **FLOATING
C2260 NB.t6 VSS 0.25605f ; **FLOATING
C2261 NB.t5 VSS 0.25605f ; **FLOATING
C2262 NB.t4 VSS 0.25605f ; **FLOATING
C2263 NB.t3 VSS 0.25605f ; **FLOATING
C2264 NB.t2 VSS 0.25605f ; **FLOATING
C2265 NB.t1 VSS 0.25605f ; **FLOATING
C2266 NB.t0 VSS 0.33214f ; **FLOATING
C2267 NB.n1 VSS 0.18151f ; **FLOATING
C2268 NB.n2 VSS 0.12966f ; **FLOATING
C2269 NB.n3 VSS 0.12966f ; **FLOATING
C2270 NB.n4 VSS 0.12966f ; **FLOATING
C2271 NB.n5 VSS 0.12966f ; **FLOATING
C2272 NB.n6 VSS 0.12966f ; **FLOATING
C2273 NB.n7 VSS 0.12966f ; **FLOATING
C2274 NB.n8 VSS 0.12966f ; **FLOATING
C2275 NB.n9 VSS 0.12966f ; **FLOATING
C2276 NB.n10 VSS 0.12966f ; **FLOATING
C2277 NB.n11 VSS 0.12966f ; **FLOATING
C2278 NB.n12 VSS 0.12966f ; **FLOATING
C2279 NB.n13 VSS 0.12966f ; **FLOATING
C2280 NB.n14 VSS 0.12966f ; **FLOATING
C2281 NB.n15 VSS 0.12966f ; **FLOATING
C2282 NB.n16 VSS 0.12966f ; **FLOATING
C2283 NB.n17 VSS 0.12966f ; **FLOATING
C2284 NB.n18 VSS 0.12966f ; **FLOATING
C2285 NB.n19 VSS 0.12047f ; **FLOATING
C2286 NB.t20 VSS 0.25605f ; **FLOATING
C2287 NB.t21 VSS 0.25605f ; **FLOATING
C2288 NB.t22 VSS 0.25605f ; **FLOATING
C2289 NB.t23 VSS 0.25605f ; **FLOATING
C2290 NB.t24 VSS 0.25605f ; **FLOATING
C2291 NB.t25 VSS 0.25605f ; **FLOATING
C2292 NB.t26 VSS 0.25605f ; **FLOATING
C2293 NB.t27 VSS 0.25605f ; **FLOATING
C2294 NB.t28 VSS 0.25605f ; **FLOATING
C2295 NB.t29 VSS 0.25605f ; **FLOATING
C2296 NB.t30 VSS 0.25605f ; **FLOATING
C2297 NB.t31 VSS 0.25605f ; **FLOATING
C2298 NB.t32 VSS 0.25605f ; **FLOATING
C2299 NB.t33 VSS 0.25605f ; **FLOATING
C2300 NB.t34 VSS 0.25605f ; **FLOATING
C2301 NB.t35 VSS 0.25605f ; **FLOATING
C2302 NB.t36 VSS 0.25605f ; **FLOATING
C2303 NB.t37 VSS 0.25605f ; **FLOATING
C2304 NB.t38 VSS 0.25605f ; **FLOATING
C2305 NB.t39 VSS 0.33214f ; **FLOATING
C2306 NB.n20 VSS 0.18151f ; **FLOATING
C2307 NB.n21 VSS 0.12966f ; **FLOATING
C2308 NB.n22 VSS 0.12966f ; **FLOATING
C2309 NB.n23 VSS 0.12966f ; **FLOATING
C2310 NB.n24 VSS 0.12966f ; **FLOATING
C2311 NB.n25 VSS 0.12966f ; **FLOATING
C2312 NB.n26 VSS 0.12966f ; **FLOATING
C2313 NB.n27 VSS 0.12966f ; **FLOATING
C2314 NB.n28 VSS 0.12966f ; **FLOATING
C2315 NB.n29 VSS 0.12966f ; **FLOATING
C2316 NB.n30 VSS 0.12966f ; **FLOATING
C2317 NB.n31 VSS 0.12966f ; **FLOATING
C2318 NB.n32 VSS 0.12966f ; **FLOATING
C2319 NB.n33 VSS 0.12966f ; **FLOATING
C2320 NB.n34 VSS 0.12966f ; **FLOATING
C2321 NB.n35 VSS 0.12966f ; **FLOATING
C2322 NB.n36 VSS 0.12966f ; **FLOATING
C2323 NB.n37 VSS 0.12966f ; **FLOATING
C2324 NB.n38 VSS 0.12047f ; **FLOATING
C2325 NB.n39 VSS 1.45592f ; **FLOATING
C2326 NB.t59 VSS 0.25605f ; **FLOATING
C2327 NB.t58 VSS 0.25605f ; **FLOATING
C2328 NB.t57 VSS 0.25605f ; **FLOATING
C2329 NB.t56 VSS 0.25605f ; **FLOATING
C2330 NB.t55 VSS 0.25605f ; **FLOATING
C2331 NB.t54 VSS 0.25605f ; **FLOATING
C2332 NB.t53 VSS 0.25605f ; **FLOATING
C2333 NB.t52 VSS 0.25605f ; **FLOATING
C2334 NB.t51 VSS 0.25605f ; **FLOATING
C2335 NB.t50 VSS 0.25605f ; **FLOATING
C2336 NB.t49 VSS 0.25605f ; **FLOATING
C2337 NB.t48 VSS 0.25605f ; **FLOATING
C2338 NB.t47 VSS 0.25605f ; **FLOATING
C2339 NB.t46 VSS 0.25605f ; **FLOATING
C2340 NB.t45 VSS 0.25605f ; **FLOATING
C2341 NB.t44 VSS 0.25605f ; **FLOATING
C2342 NB.t43 VSS 0.25605f ; **FLOATING
C2343 NB.t42 VSS 0.25605f ; **FLOATING
C2344 NB.t41 VSS 0.25605f ; **FLOATING
C2345 NB.t40 VSS 0.33301f ; **FLOATING
C2346 NB.n40 VSS 0.19243f ; **FLOATING
C2347 NB.n41 VSS 0.13555f ; **FLOATING
C2348 NB.n42 VSS 0.13555f ; **FLOATING
C2349 NB.n43 VSS 0.13555f ; **FLOATING
C2350 NB.n44 VSS 0.13555f ; **FLOATING
C2351 NB.n45 VSS 0.13555f ; **FLOATING
C2352 NB.n46 VSS 0.13555f ; **FLOATING
C2353 NB.n47 VSS 0.13555f ; **FLOATING
C2354 NB.n48 VSS 0.13555f ; **FLOATING
C2355 NB.n49 VSS 0.13555f ; **FLOATING
C2356 NB.n50 VSS 0.13555f ; **FLOATING
C2357 NB.n51 VSS 0.13555f ; **FLOATING
C2358 NB.n52 VSS 0.13555f ; **FLOATING
C2359 NB.n53 VSS 0.13555f ; **FLOATING
C2360 NB.n54 VSS 0.13555f ; **FLOATING
C2361 NB.n55 VSS 0.13555f ; **FLOATING
C2362 NB.n56 VSS 0.13555f ; **FLOATING
C2363 NB.n57 VSS 0.13555f ; **FLOATING
C2364 NB.n58 VSS 0.12582f ; **FLOATING
C2365 NB.t60 VSS 0.25605f ; **FLOATING
C2366 NB.t61 VSS 0.25605f ; **FLOATING
C2367 NB.t62 VSS 0.25605f ; **FLOATING
C2368 NB.t63 VSS 0.25605f ; **FLOATING
C2369 NB.t64 VSS 0.25605f ; **FLOATING
C2370 NB.t65 VSS 0.25605f ; **FLOATING
C2371 NB.t66 VSS 0.25605f ; **FLOATING
C2372 NB.t67 VSS 0.25605f ; **FLOATING
C2373 NB.t68 VSS 0.25605f ; **FLOATING
C2374 NB.t69 VSS 0.25605f ; **FLOATING
C2375 NB.t70 VSS 0.25605f ; **FLOATING
C2376 NB.t71 VSS 0.25605f ; **FLOATING
C2377 NB.t72 VSS 0.25605f ; **FLOATING
C2378 NB.t73 VSS 0.25605f ; **FLOATING
C2379 NB.t74 VSS 0.25605f ; **FLOATING
C2380 NB.t75 VSS 0.25605f ; **FLOATING
C2381 NB.t76 VSS 0.25605f ; **FLOATING
C2382 NB.t77 VSS 0.25605f ; **FLOATING
C2383 NB.t78 VSS 0.25605f ; **FLOATING
C2384 NB.t79 VSS 0.33301f ; **FLOATING
C2385 NB.n59 VSS 0.19243f ; **FLOATING
C2386 NB.n60 VSS 0.13555f ; **FLOATING
C2387 NB.n61 VSS 0.13555f ; **FLOATING
C2388 NB.n62 VSS 0.13555f ; **FLOATING
C2389 NB.n63 VSS 0.13555f ; **FLOATING
C2390 NB.n64 VSS 0.13555f ; **FLOATING
C2391 NB.n65 VSS 0.13555f ; **FLOATING
C2392 NB.n66 VSS 0.13555f ; **FLOATING
C2393 NB.n67 VSS 0.13555f ; **FLOATING
C2394 NB.n68 VSS 0.13555f ; **FLOATING
C2395 NB.n69 VSS 0.13555f ; **FLOATING
C2396 NB.n70 VSS 0.13555f ; **FLOATING
C2397 NB.n71 VSS 0.13555f ; **FLOATING
C2398 NB.n72 VSS 0.13555f ; **FLOATING
C2399 NB.n73 VSS 0.13555f ; **FLOATING
C2400 NB.n74 VSS 0.13555f ; **FLOATING
C2401 NB.n75 VSS 0.13555f ; **FLOATING
C2402 NB.n76 VSS 0.13555f ; **FLOATING
C2403 NB.n77 VSS 0.12582f ; **FLOATING
C2404 NB.n78 VSS 1.43023f ; **FLOATING
C2405 NB.n79 VSS 0.35708f ; **FLOATING
C2406 NB.t99 VSS 0.25605f ; **FLOATING
C2407 NB.t98 VSS 0.25605f ; **FLOATING
C2408 NB.t97 VSS 0.25605f ; **FLOATING
C2409 NB.t96 VSS 0.25605f ; **FLOATING
C2410 NB.t95 VSS 0.25605f ; **FLOATING
C2411 NB.t94 VSS 0.25605f ; **FLOATING
C2412 NB.t93 VSS 0.25605f ; **FLOATING
C2413 NB.t92 VSS 0.25605f ; **FLOATING
C2414 NB.t91 VSS 0.25605f ; **FLOATING
C2415 NB.t90 VSS 0.25605f ; **FLOATING
C2416 NB.t89 VSS 0.25605f ; **FLOATING
C2417 NB.t88 VSS 0.25605f ; **FLOATING
C2418 NB.t87 VSS 0.25605f ; **FLOATING
C2419 NB.t86 VSS 0.25605f ; **FLOATING
C2420 NB.t85 VSS 0.25605f ; **FLOATING
C2421 NB.t84 VSS 0.25605f ; **FLOATING
C2422 NB.t83 VSS 0.25605f ; **FLOATING
C2423 NB.t82 VSS 0.25605f ; **FLOATING
C2424 NB.t81 VSS 0.25605f ; **FLOATING
C2425 NB.t80 VSS 0.33301f ; **FLOATING
C2426 NB.n80 VSS 0.19243f ; **FLOATING
C2427 NB.n81 VSS 0.13555f ; **FLOATING
C2428 NB.n82 VSS 0.13555f ; **FLOATING
C2429 NB.n83 VSS 0.13555f ; **FLOATING
C2430 NB.n84 VSS 0.13555f ; **FLOATING
C2431 NB.n85 VSS 0.13555f ; **FLOATING
C2432 NB.n86 VSS 0.13555f ; **FLOATING
C2433 NB.n87 VSS 0.13555f ; **FLOATING
C2434 NB.n88 VSS 0.13555f ; **FLOATING
C2435 NB.n89 VSS 0.13555f ; **FLOATING
C2436 NB.n90 VSS 0.13555f ; **FLOATING
C2437 NB.n91 VSS 0.13555f ; **FLOATING
C2438 NB.n92 VSS 0.13555f ; **FLOATING
C2439 NB.n93 VSS 0.13555f ; **FLOATING
C2440 NB.n94 VSS 0.13555f ; **FLOATING
C2441 NB.n95 VSS 0.13555f ; **FLOATING
C2442 NB.n96 VSS 0.13555f ; **FLOATING
C2443 NB.n97 VSS 0.13555f ; **FLOATING
C2444 NB.n98 VSS 0.12582f ; **FLOATING
C2445 NB.t100 VSS 0.25605f ; **FLOATING
C2446 NB.t101 VSS 0.25605f ; **FLOATING
C2447 NB.t102 VSS 0.25605f ; **FLOATING
C2448 NB.t103 VSS 0.25605f ; **FLOATING
C2449 NB.t104 VSS 0.25605f ; **FLOATING
C2450 NB.t105 VSS 0.25605f ; **FLOATING
C2451 NB.t106 VSS 0.25605f ; **FLOATING
C2452 NB.t107 VSS 0.25605f ; **FLOATING
C2453 NB.t108 VSS 0.25605f ; **FLOATING
C2454 NB.t109 VSS 0.25605f ; **FLOATING
C2455 NB.t110 VSS 0.25605f ; **FLOATING
C2456 NB.t111 VSS 0.25605f ; **FLOATING
C2457 NB.t112 VSS 0.25605f ; **FLOATING
C2458 NB.t113 VSS 0.25605f ; **FLOATING
C2459 NB.t114 VSS 0.25605f ; **FLOATING
C2460 NB.t115 VSS 0.25605f ; **FLOATING
C2461 NB.t116 VSS 0.25605f ; **FLOATING
C2462 NB.t117 VSS 0.25605f ; **FLOATING
C2463 NB.t118 VSS 0.25605f ; **FLOATING
C2464 NB.t119 VSS 0.33301f ; **FLOATING
C2465 NB.n99 VSS 0.19243f ; **FLOATING
C2466 NB.n100 VSS 0.13555f ; **FLOATING
C2467 NB.n101 VSS 0.13555f ; **FLOATING
C2468 NB.n102 VSS 0.13555f ; **FLOATING
C2469 NB.n103 VSS 0.13555f ; **FLOATING
C2470 NB.n104 VSS 0.13555f ; **FLOATING
C2471 NB.n105 VSS 0.13555f ; **FLOATING
C2472 NB.n106 VSS 0.13555f ; **FLOATING
C2473 NB.n107 VSS 0.13555f ; **FLOATING
C2474 NB.n108 VSS 0.13555f ; **FLOATING
C2475 NB.n109 VSS 0.13555f ; **FLOATING
C2476 NB.n110 VSS 0.13555f ; **FLOATING
C2477 NB.n111 VSS 0.13555f ; **FLOATING
C2478 NB.n112 VSS 0.13555f ; **FLOATING
C2479 NB.n113 VSS 0.13555f ; **FLOATING
C2480 NB.n114 VSS 0.13555f ; **FLOATING
C2481 NB.n115 VSS 0.13555f ; **FLOATING
C2482 NB.n116 VSS 0.13555f ; **FLOATING
C2483 NB.n117 VSS 0.12582f ; **FLOATING
C2484 NB.n118 VSS 1.43023f ; **FLOATING
C2485 NB.n119 VSS 0.20628f ; **FLOATING
C2486 NB.t139 VSS 0.25605f ; **FLOATING
C2487 NB.t138 VSS 0.25605f ; **FLOATING
C2488 NB.t137 VSS 0.25605f ; **FLOATING
C2489 NB.t136 VSS 0.25605f ; **FLOATING
C2490 NB.t135 VSS 0.25605f ; **FLOATING
C2491 NB.t134 VSS 0.25605f ; **FLOATING
C2492 NB.t133 VSS 0.25605f ; **FLOATING
C2493 NB.t132 VSS 0.25605f ; **FLOATING
C2494 NB.t131 VSS 0.25605f ; **FLOATING
C2495 NB.t130 VSS 0.25605f ; **FLOATING
C2496 NB.t129 VSS 0.25605f ; **FLOATING
C2497 NB.t128 VSS 0.25605f ; **FLOATING
C2498 NB.t127 VSS 0.25605f ; **FLOATING
C2499 NB.t126 VSS 0.25605f ; **FLOATING
C2500 NB.t125 VSS 0.25605f ; **FLOATING
C2501 NB.t124 VSS 0.25605f ; **FLOATING
C2502 NB.t123 VSS 0.25605f ; **FLOATING
C2503 NB.t122 VSS 0.25605f ; **FLOATING
C2504 NB.t121 VSS 0.25605f ; **FLOATING
C2505 NB.t120 VSS 0.33301f ; **FLOATING
C2506 NB.n120 VSS 0.19243f ; **FLOATING
C2507 NB.n121 VSS 0.13555f ; **FLOATING
C2508 NB.n122 VSS 0.13555f ; **FLOATING
C2509 NB.n123 VSS 0.13555f ; **FLOATING
C2510 NB.n124 VSS 0.13555f ; **FLOATING
C2511 NB.n125 VSS 0.13555f ; **FLOATING
C2512 NB.n126 VSS 0.13555f ; **FLOATING
C2513 NB.n127 VSS 0.13555f ; **FLOATING
C2514 NB.n128 VSS 0.13555f ; **FLOATING
C2515 NB.n129 VSS 0.13555f ; **FLOATING
C2516 NB.n130 VSS 0.13555f ; **FLOATING
C2517 NB.n131 VSS 0.13555f ; **FLOATING
C2518 NB.n132 VSS 0.13555f ; **FLOATING
C2519 NB.n133 VSS 0.13555f ; **FLOATING
C2520 NB.n134 VSS 0.13555f ; **FLOATING
C2521 NB.n135 VSS 0.13555f ; **FLOATING
C2522 NB.n136 VSS 0.13555f ; **FLOATING
C2523 NB.n137 VSS 0.13555f ; **FLOATING
C2524 NB.n138 VSS 0.12582f ; **FLOATING
C2525 NB.t140 VSS 0.25605f ; **FLOATING
C2526 NB.t141 VSS 0.25605f ; **FLOATING
C2527 NB.t142 VSS 0.25605f ; **FLOATING
C2528 NB.t143 VSS 0.25605f ; **FLOATING
C2529 NB.t144 VSS 0.25605f ; **FLOATING
C2530 NB.t145 VSS 0.25605f ; **FLOATING
C2531 NB.t146 VSS 0.25605f ; **FLOATING
C2532 NB.t147 VSS 0.25605f ; **FLOATING
C2533 NB.t148 VSS 0.25605f ; **FLOATING
C2534 NB.t149 VSS 0.25605f ; **FLOATING
C2535 NB.t150 VSS 0.25605f ; **FLOATING
C2536 NB.t151 VSS 0.25605f ; **FLOATING
C2537 NB.t152 VSS 0.25605f ; **FLOATING
C2538 NB.t153 VSS 0.25605f ; **FLOATING
C2539 NB.t154 VSS 0.25605f ; **FLOATING
C2540 NB.t155 VSS 0.25605f ; **FLOATING
C2541 NB.t156 VSS 0.25605f ; **FLOATING
C2542 NB.t157 VSS 0.25605f ; **FLOATING
C2543 NB.t158 VSS 0.25605f ; **FLOATING
C2544 NB.t159 VSS 0.33301f ; **FLOATING
C2545 NB.n139 VSS 0.19243f ; **FLOATING
C2546 NB.n140 VSS 0.13555f ; **FLOATING
C2547 NB.n141 VSS 0.13555f ; **FLOATING
C2548 NB.n142 VSS 0.13555f ; **FLOATING
C2549 NB.n143 VSS 0.13555f ; **FLOATING
C2550 NB.n144 VSS 0.13555f ; **FLOATING
C2551 NB.n145 VSS 0.13555f ; **FLOATING
C2552 NB.n146 VSS 0.13555f ; **FLOATING
C2553 NB.n147 VSS 0.13555f ; **FLOATING
C2554 NB.n148 VSS 0.13555f ; **FLOATING
C2555 NB.n149 VSS 0.13555f ; **FLOATING
C2556 NB.n150 VSS 0.13555f ; **FLOATING
C2557 NB.n151 VSS 0.13555f ; **FLOATING
C2558 NB.n152 VSS 0.13555f ; **FLOATING
C2559 NB.n153 VSS 0.13555f ; **FLOATING
C2560 NB.n154 VSS 0.13555f ; **FLOATING
C2561 NB.n155 VSS 0.13555f ; **FLOATING
C2562 NB.n156 VSS 0.13555f ; **FLOATING
C2563 NB.n157 VSS 0.12582f ; **FLOATING
C2564 NB.n158 VSS 1.43023f ; **FLOATING
C2565 NB.n159 VSS 1.17201f ; **FLOATING
C2566 NB.n160 VSS 1.57677f ; **FLOATING
C2567 G1A.t4 VSS 0.73661f ; **FLOATING
C2568 G1A.t5 VSS 3.49558f ; **FLOATING
C2569 G1A.t2 VSS 0.24284f ; **FLOATING
C2570 G1A.n0 VSS 10.5301f ; **FLOATING
C2571 G1A.t3 VSS 0.88945f ; **FLOATING
C2572 G1A.n1 VSS 1.44775f ; **FLOATING
C2573 G1A.n2 VSS 1.71139f ; **FLOATING
C2574 G1A.t0 VSS 0.18704f ; **FLOATING
C2575 G1A.n3 VSS 2.24913f ; **FLOATING
C2576 G1A.t1 VSS 0.14508f ; **FLOATING
C2577 G1A.n4 VSS 9.17394f ; **FLOATING
C2578 OUTN.n0 VSS 2.09643f ; **FLOATING
C2579 OUTN.n1 VSS 4.84258f ; **FLOATING
C2580 OUTN.t1 VSS 0.55097f ; **FLOATING
C2581 OUTN.t4 VSS 0.52433f ; **FLOATING
C2582 OUTN.t3 VSS 0.52433f ; **FLOATING
C2583 OUTN.t2 VSS 0.52548f ; **FLOATING
C2584 OUTN.t13 VSS 0.73323f ; **FLOATING
C2585 OUTN.t10 VSS 0.64122f ; **FLOATING
C2586 OUTN.t7 VSS 0.64382f ; **FLOATING
C2587 OUTN.t15 VSS 0.64264f ; **FLOATING
C2588 OUTN.t6 VSS 0.69223f ; **FLOATING
C2589 OUTN.t5 VSS 0.64473f ; **FLOATING
C2590 OUTN.t8 VSS 0.64356f ; **FLOATING
C2591 OUTN.t0 VSS 0.7234f ; **FLOATING
C2592 OUTN.n2 VSS 0.63659f ; **FLOATING
C2593 OUTN.n3 VSS 0.36861f ; **FLOATING
C2594 OUTN.n4 VSS 0.67005f ; **FLOATING
C2595 OUTN.n5 VSS 0.24224f ; **FLOATING
C2596 OUTN.n6 VSS 0.8873f ; **FLOATING
C2597 OUTN.t14 VSS 0.44751f ; **FLOATING
C2598 OUTN.t12 VSS 0.4211f ; **FLOATING
C2599 OUTN.n7 VSS 0.4628f ; **FLOATING
C2600 OUTN.t9 VSS 0.44751f ; **FLOATING
C2601 OUTN.t11 VSS 0.4211f ; **FLOATING
C2602 OUTN.n8 VSS 0.4628f ; **FLOATING
C2603 OUTN.n9 VSS 0.97734f ; **FLOATING
C2604 OUTN.n10 VSS 1.09441f ; **FLOATING
C2605 OUTN.n11 VSS 13.178f ; **FLOATING
C2606 OUTP.n0 VSS 5.61825f ; **FLOATING
C2607 OUTP.n1 VSS 1.76418f ; **FLOATING
C2608 OUTP.n2 VSS 0.74497f ; **FLOATING
C2609 OUTP.t12 VSS 0.61457f ; **FLOATING
C2610 OUTP.t11 VSS 0.58581f ; **FLOATING
C2611 OUTP.t10 VSS 0.58581f ; **FLOATING
C2612 OUTP.t9 VSS 0.5863f ; **FLOATING
C2613 OUTP.t4 VSS 0.72681f ; **FLOATING
C2614 OUTP.t1 VSS 0.71221f ; **FLOATING
C2615 OUTP.t13 VSS 0.71813f ; **FLOATING
C2616 OUTP.t15 VSS 0.71702f ; **FLOATING
C2617 OUTP.t8 VSS 0.72606f ; **FLOATING
C2618 OUTP.t6 VSS 0.71881f ; **FLOATING
C2619 OUTP.t7 VSS 0.7177f ; **FLOATING
C2620 OUTP.t14 VSS 0.80498f ; **FLOATING
C2621 OUTP.n3 VSS 0.4774f ; **FLOATING
C2622 OUTP.n4 VSS 0.41508f ; **FLOATING
C2623 OUTP.n5 VSS 1.1469f ; **FLOATING
C2624 OUTP.t5 VSS 0.49723f ; **FLOATING
C2625 OUTP.t3 VSS 0.46752f ; **FLOATING
C2626 OUTP.n6 VSS 0.41998f ; **FLOATING
C2627 OUTP.t0 VSS 0.49723f ; **FLOATING
C2628 OUTP.t2 VSS 0.46752f ; **FLOATING
C2629 OUTP.n7 VSS 0.41998f ; **FLOATING
C2630 OUTP.n8 VSS 0.445f ; **FLOATING
C2631 OUTP.n9 VSS 0.53892f ; **FLOATING
C2632 OUTP.n10 VSS 11.0396f ; **FLOATING
C2633 G1B.t5 VSS 0.49722f ; **FLOATING
C2634 G1B.t2 VSS 0.19235f ; **FLOATING
C2635 G1B.t3 VSS 0.16179f ; **FLOATING
C2636 G1B.n0 VSS 1.19455f ; **FLOATING
C2637 G1B.t4 VSS 0.59446f ; **FLOATING
C2638 G1B.n1 VSS 0.78382f ; **FLOATING
C2639 G1B.n2 VSS 1.27567f ; **FLOATING
C2640 G1B.t0 VSS 0.12384f ; **FLOATING
C2641 G1B.n3 VSS 1.74974f ; **FLOATING
C2642 G1B.t1 VSS 0.09793f ; **FLOATING
C2643 G1B.n4 VSS 7.71944f ; **FLOATING
C2644 G2A.t2 VSS 0.24946f ; **FLOATING
C2645 G2A.t5 VSS 0.89826f ; **FLOATING
C2646 G2A.t3 VSS 0.31696f ; **FLOATING
C2647 G2A.t4 VSS 1.07393f ; **FLOATING
C2648 G2A.n0 VSS 2.10178f ; **FLOATING
C2649 G2A.n1 VSS 2.85837f ; **FLOATING
C2650 G2A.t0 VSS 0.22808f ; **FLOATING
C2651 G2A.n2 VSS 4.05068f ; **FLOATING
C2652 G2A.t1 VSS 0.23511f ; **FLOATING
C2653 G2A.n3 VSS 10.6045f ; **FLOATING
C2654 G2A.n4 VSS 14.7346f ; **FLOATING
C2655 G2B.t4 VSS 0.85386f ; **FLOATING
C2656 G2B.t0 VSS 0.29133f ; **FLOATING
C2657 G2B.t1 VSS 0.22482f ; **FLOATING
C2658 G2B.n0 VSS 9.88795f ; **FLOATING
C2659 G2B.t2 VSS 0.27784f ; **FLOATING
C2660 G2B.n1 VSS 8.19141f ; **FLOATING
C2661 G2B.t3 VSS 0.27784f ; **FLOATING
C2662 G2B.n2 VSS 1.46727f ; **FLOATING
C2663 G2B.n3 VSS 0.88305f ; **FLOATING
C2664 G2B.t5 VSS 0.85032f ; **FLOATING
C2665 G2B.n4 VSS 8.80827f ; **FLOATING
C2666 G3A.t4 VSS 0.73808f ; **FLOATING
C2667 G3A.t0 VSS 0.24053f ; **FLOATING
C2668 G3A.t1 VSS 0.18741f ; **FLOATING
C2669 G3A.n0 VSS 7.80923f ; **FLOATING
C2670 G3A.t2 VSS 0.24333f ; **FLOATING
C2671 G3A.n1 VSS 6.59395f ; **FLOATING
C2672 G3A.t3 VSS 0.24333f ; **FLOATING
C2673 G3A.n2 VSS 1.32775f ; **FLOATING
C2674 G3A.n3 VSS 0.78982f ; **FLOATING
C2675 G3A.t5 VSS 0.73502f ; **FLOATING
C2676 G3A.n4 VSS 10.3488f ; **FLOATING
C2677 G3B.t5 VSS 0.44124f ; **FLOATING
C2678 G3B.t2 VSS 0.17069f ; **FLOATING
C2679 G3B.t3 VSS 0.14357f ; **FLOATING
C2680 G3B.n0 VSS 1.06005f ; **FLOATING
C2681 G3B.t4 VSS 0.52753f ; **FLOATING
C2682 G3B.n1 VSS 0.69556f ; **FLOATING
C2683 G3B.n2 VSS 2.38528f ; **FLOATING
C2684 G3B.t0 VSS 0.10989f ; **FLOATING
C2685 G3B.n3 VSS 3.13792f ; **FLOATING
C2686 G3B.t1 VSS 0.0869f ; **FLOATING
C2687 G3B.n4 VSS 5.7491f ; **FLOATING
C2688 INP.t0 VSS 10.2718f ; **FLOATING
.ends
