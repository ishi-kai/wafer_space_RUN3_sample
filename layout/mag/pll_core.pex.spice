* NGSPICE file created from pll_core_flat.ext - technology: gf180mcuD

.subckt pll_core_flat VSS VDD REFCK LO NB PB ICP2 VCTRL FS FB REFCK_O
X0 a_129500_21760# NB.t1 VSS VSS nfet_03v3 ad=2.12p pd=8.53u as=2.12p ps=8.53u w=8u l=2u
X1 a_121569_21999.t3 a_121493_21789# a_121869_26660# VDD pfet_03v3 ad=1.06p pd=4.53u as=1.06p ps=4.53u w=4u l=0.28u
X2 a_121569_21999.t0 a_20585_21760.t3 a_129500_21760# VSS nfet_03v3 ad=0.89p pd=4.89u as=0.89p ps=4.89u w=2u l=0.28u
X3 a_161285_35122# a_159605_39260# VDD VDD pfet_03v3 ad=0.89p pd=4.89u as=0.89p ps=4.89u w=2u l=0.28u
X4 a_162965_39260# a_161140_39260# VDD VDD pfet_03v3 ad=1.78p pd=8.89u as=1.78p ps=8.89u w=4u l=0.28u
X5 a_183125_39602# a_154565_43880# VSS VSS nfet_03v3 ad=0.445p pd=2.89u as=0.445p ps=2.89u w=1u l=0.28u
X6 a_151205_35122# a_151087_35509# VDD VDD pfet_03v3 ad=0.89p pd=4.89u as=0.89p ps=4.89u w=2u l=0.28u
X7 a_3640_39120# a_5347_39849# VSS VSS nfet_03v3 ad=1.335p pd=6.89u as=1.335p ps=6.89u w=3u l=0.28u
X8 a_3785_21760# a_7027_22349.t1 VDD VDD pfet_03v3 ad=0.89p pd=4.89u as=0.89p ps=4.89u w=2u l=0.28u
X9 a_157925_30440# a_156100_30440# VDD VDD pfet_03v3 ad=1.78p pd=8.89u as=1.78p ps=8.89u w=4u l=0.28u
X10 a_121100_21999# a_18905_21760.t2 a_34200_24066.t1 VDD pfet_03v3 ad=1.06p pd=4.53u as=1.06p ps=4.53u w=4u l=0.28u
X11 a_3667_31029# a_5347_22349# VDD VDD pfet_03v3 ad=0.89p pd=4.89u as=0.89p ps=4.89u w=2u l=0.28u
X12 a_164645_35122# a_162965_39260# VSS VSS nfet_03v3 ad=0.89p pd=4.89u as=0.89p ps=4.89u w=2u l=0.28u
X13 a_159605_39260# a_157780_39260# VDD VDD pfet_03v3 ad=1.78p pd=8.89u as=1.78p ps=8.89u w=4u l=0.28u
X14 a_152885_21760# FB.t1 VDD VDD pfet_03v3 ad=1.78p pd=8.89u as=1.78p ps=8.89u w=4u l=0.28u
X15 a_154565_35122.t2 a_154447_40129# VSS VSS nfet_03v3 ad=0.89p pd=4.89u as=0.89p ps=4.89u w=2u l=0.28u
X16 a_3667_26689# a_13865_30440# a_18760_43600# VSS nfet_03v3 ad=1.335p pd=6.89u as=1.335p ps=6.89u w=3u l=0.28u
X17 a_154565_43880# a_152740_43880# VDD VDD pfet_03v3 ad=1.78p pd=8.89u as=1.78p ps=8.89u w=4u l=0.28u
X18 a_5465_21760# a_5347_22349# a_5320_21760# VSS nfet_03v3 ad=0.89p pd=4.89u as=0.89p ps=4.89u w=2u l=0.28u
X19 a_169567_35509# a_151087_22349# a_151060_21760# VSS nfet_03v3 ad=0.89p pd=4.89u as=0.89p ps=4.89u w=2u l=0.28u
X20 a_156245_39260# a_154565_39260# VSS VSS nfet_03v3 ad=0.89p pd=4.89u as=0.89p ps=4.89u w=2u l=0.28u
X21 a_152767_35509# a_154447_35509# VSS VSS nfet_03v3 ad=0.89p pd=4.89u as=0.89p ps=4.89u w=2u l=0.28u
X22 VDD PB.t4 a_121869_26660# VDD pfet_03v3 ad=2.12p pd=8.53u as=2.12p ps=8.53u w=8u l=2u
X23 a_3667_5549# LO cap_mim_2f0_m4m5_noshield c_width=5u c_length=5u
X24 VCTRL.t1 VSS cap_mim_2f0_m4m5_noshield c_width=5u c_length=5u
X25 a_121100_21999# a_121493_21789# a_121569_21999.t0 VDD pfet_03v3 ad=1.78p pd=8.89u as=1.06p ps=4.53u w=4u l=0.28u
X26 a_17080_34780# a_3667_22349.t7 VSS VSS nfet_03v3 ad=0.89p pd=4.89u as=0.89p ps=4.89u w=2u l=0.28u
X27 VSS NB.t8 a_129500_21760# VSS nfet_03v3 ad=2.12p pd=8.53u as=2.12p ps=8.53u w=8u l=2u
X28 a_34200_24066.t1 a_18905_21760.t3 a_121100_21999# VDD pfet_03v3 ad=1.06p pd=4.53u as=1.78p ps=8.89u w=4u l=0.28u
X29 a_3785_30440# a_3667_31029# VSS VSS nfet_03v3 ad=0.89p pd=4.89u as=0.89p ps=4.89u w=2u l=0.28u
X30 a_149525_21760.t5 a_169685_39260# a_171220_35122# VSS nfet_03v3 ad=0.89p pd=4.89u as=0.89p ps=4.89u w=2u l=0.28u
X31 a_166325_39260# a_151205_39260# VDD VDD pfet_03v3 ad=1.78p pd=8.89u as=1.78p ps=8.89u w=4u l=0.28u
X32 a_149407_35509# a_149407_31029# VDD VDD pfet_03v3 ad=1.78p pd=8.89u as=1.78p ps=8.89u w=4u l=0.28u
X33 a_12627_2049# a_15987_2189# VDD VDD pfet_03v3 ad=0.445p pd=2.89u as=0.445p ps=2.89u w=1u l=0.28u
X34 a_3785_3840# a_3667_5549# VSS VSS nfet_03v3 ad=1.78p pd=8.89u as=1.78p ps=8.89u w=4u l=0.28u
X35 a_15545_21760# a_13865_21760# VDD VDD pfet_03v3 ad=0.89p pd=4.89u as=0.89p ps=4.89u w=2u l=0.28u
X36 a_18905_21760.t0 a_5347_22349# VSS VSS nfet_03v3 ad=0.445p pd=2.89u as=0.445p ps=2.89u w=1u l=0.28u
X37 a_169685_35122# a_151087_22349# a_171220_35122# VSS nfet_03v3 ad=0.445p pd=2.89u as=0.445p ps=2.89u w=1u l=0.28u
X38 a_154565_43880# a_152740_43880# VSS VSS nfet_03v3 ad=0.89p pd=4.89u as=0.89p ps=4.89u w=2u l=0.28u
X39 a_154565_39260# a_154447_40129# VDD VDD pfet_03v3 ad=1.78p pd=8.89u as=1.78p ps=8.89u w=4u l=0.28u
X40 a_152885_39260# a_154447_26689.t2 a_149380_39260# VDD pfet_03v3 ad=0.89p pd=4.89u as=0.89p ps=4.89u w=2u l=0.28u
X41 a_123769_21999# a_34200_24066.t1 a_123480_21999# VSS nfet_03v3 ad=1.06p pd=4.53u as=1.78p ps=8.89u w=4u l=1u
X42 a_3667_31029# a_5347_22349# a_13720_43600# VSS nfet_03v3 ad=1.335p pd=6.89u as=1.335p ps=6.89u w=3u l=0.28u
X43 a_8680_39120# a_3667_22349.t9 VSS VSS nfet_03v3 ad=1.335p pd=6.89u as=1.335p ps=6.89u w=3u l=0.28u
X44 a_121869_26660# a_18905_21760.t4 a_34200_24066.t0 VDD pfet_03v3 ad=1.06p pd=4.53u as=1.06p ps=4.53u w=4u l=0.28u
X45 VCTRL.t1 VSS cap_mim_2f0_m4m5_noshield c_width=5u c_length=5u
X46 a_34200_24066.t1 a_7027_22349.t2 a_131180_21760# VSS nfet_03v3 ad=0.89p pd=4.89u as=0.89p ps=4.89u w=2u l=0.28u
X47 a_149525_21760.t2 a_151087_22349# a_151060_21760# VDD pfet_03v3 ad=0.89p pd=4.89u as=0.89p ps=4.89u w=2u l=0.28u
X48 VDD a_123769_21999# a_121569_21999.t0 VDD pfet_03v3 ad=1.78p pd=8.89u as=1.06p ps=4.53u w=4u l=1u
X49 a_159605_39260# a_157780_39260# VSS VSS nfet_03v3 ad=0.89p pd=4.89u as=0.89p ps=4.89u w=2u l=0.28u
X50 a_7027_22349.t1 a_3667_26689# VDD VDD pfet_03v3 ad=0.89p pd=4.89u as=0.89p ps=4.89u w=2u l=0.28u
X51 a_151087_35509# a_154447_35509# a_154420_35122# VDD pfet_03v3 ad=1.78p pd=8.89u as=1.78p ps=8.89u w=4u l=0.28u
X52 a_149407_31029# a_151060_30440# VSS VSS nfet_03v3 ad=0.89p pd=4.89u as=0.89p ps=4.89u w=2u l=0.28u
X53 a_122881_26660# a_138745_34982# a_121100_21999# VDD pfet_03v3 ad=1.59p pd=6.53u as=1.59p ps=6.53u w=6u l=0.28u
X54 a_149525_26100# a_154447_26689.t3 a_149380_39260# VSS nfet_03v3 ad=0.89p pd=4.89u as=0.89p ps=4.89u w=2u l=0.28u
X55 a_159605_39260# a_154565_39260# a_161140_39260# VDD pfet_03v3 ad=1.78p pd=8.89u as=1.78p ps=8.89u w=4u l=0.28u
X56 a_121869_26660# a_121493_21789# a_121569_21999.t3 VDD pfet_03v3 ad=1.78p pd=8.89u as=1.06p ps=4.53u w=4u l=0.28u
X57 a_8825_43600# a_5347_44329# VDD VDD pfet_03v3 ad=0.89p pd=4.89u as=0.89p ps=4.89u w=2u l=0.28u
X58 VCTRL.t1 VSS cap_mim_2f0_m4m5_noshield c_width=5u c_length=5u
X59 a_5465_21760# a_7027_22349.t1 VDD VDD pfet_03v3 ad=0.89p pd=4.89u as=0.89p ps=4.89u w=2u l=0.28u
X60 a_18760_43600# FB.t7 a_20440_43600# VSS nfet_03v3 ad=1.335p pd=6.89u as=1.335p ps=6.89u w=3u l=0.28u
X61 a_154447_35509# a_164645_30440# VDD VDD pfet_03v3 ad=1.78p pd=8.89u as=1.78p ps=8.89u w=4u l=0.28u
X62 a_13865_21760# a_12185_21760# VSS VSS nfet_03v3 ad=0.445p pd=2.89u as=0.445p ps=2.89u w=1u l=0.28u
X63 VDD PB.t2 a_122881_26660# VDD pfet_03v3 ad=2.12p pd=8.53u as=2.12p ps=8.53u w=8u l=2u
X64 a_34200_24066.t0 a_18905_21760.t5 a_121869_26660# VDD pfet_03v3 ad=1.06p pd=4.53u as=1.78p ps=8.89u w=4u l=0.28u
X65 a_5347_22349# a_3667_31029# VDD VDD pfet_03v3 ad=0.89p pd=4.89u as=0.89p ps=4.89u w=2u l=0.28u
X66 VSS NB.t6 a_133241_26660# VSS nfet_03v3 ad=2.12p pd=8.53u as=2.12p ps=8.53u w=8u l=2u
X67 a_121569_21999.t0 a_121493_21789# a_121100_21999# VDD pfet_03v3 ad=1.06p pd=4.53u as=1.06p ps=4.53u w=4u l=0.28u
X68 a_154447_26689.t1 a_149407_40129# VDD VDD pfet_03v3 ad=1.78p pd=8.89u as=1.78p ps=8.89u w=4u l=0.28u
X69 a_7000_39120# a_3785_26100# a_8680_39120# VSS nfet_03v3 ad=1.335p pd=6.89u as=1.335p ps=6.89u w=3u l=0.28u
X70 a_14307_2049# a_12627_2049# VSS VSS nfet_03v3 ad=0.445p pd=2.89u as=0.445p ps=2.89u w=1u l=0.28u
X71 a_121569_21999.t0 a_123769_21999# VDD VDD pfet_03v3 ad=1.06p pd=4.53u as=1.06p ps=4.53u w=4u l=1u
X72 a_15400_43600# a_3667_22349.t11 VSS VSS nfet_03v3 ad=1.335p pd=6.89u as=1.335p ps=6.89u w=3u l=0.28u
X73 a_154565_39260# a_154447_40129# VSS VSS nfet_03v3 ad=0.89p pd=4.89u as=0.89p ps=4.89u w=2u l=0.28u
X74 a_149525_21760.t1 FB.t1 VDD VDD pfet_03v3 ad=1.78p pd=8.89u as=1.78p ps=8.89u w=4u l=0.28u
X75 a_149525_35122.t2 a_154565_30440# a_149380_35122# VDD pfet_03v3 ad=0.89p pd=4.89u as=0.89p ps=4.89u w=2u l=0.28u
X76 VSS NB.t2 a_133241_26660# VSS nfet_03v3 ad=2.12p pd=8.53u as=2.12p ps=8.53u w=8u l=2u
X77 a_34200_24066.t3 a_34200_21944# VSS ppolyf_u_1k r_width=1u r_length=10u
X78 a_3667_35369# a_8825_43600# a_17080_34780# VSS nfet_03v3 ad=0.89p pd=4.89u as=0.89p ps=4.89u w=2u l=0.28u
X79 a_3667_35369# a_8825_43600# VDD VDD pfet_03v3 ad=0.89p pd=4.89u as=0.89p ps=4.89u w=2u l=0.28u
X80 a_5347_39849# a_3667_22349.t3 VDD VDD pfet_03v3 ad=0.89p pd=4.89u as=0.89p ps=4.89u w=2u l=0.28u
X81 a_121100_21999# a_138745_34982# a_122881_26660# VDD pfet_03v3 ad=1.59p pd=6.53u as=1.59p ps=6.53u w=6u l=0.28u
X82 a_149407_31029# a_151060_30440# VDD VDD pfet_03v3 ad=1.78p pd=8.89u as=1.78p ps=8.89u w=4u l=0.28u
X83 a_166325_35122# a_162965_39260# VSS VSS nfet_03v3 ad=0.445p pd=2.89u as=0.445p ps=2.89u w=1u l=0.28u
X84 a_3667_26689# FB.t5 VDD VDD pfet_03v3 ad=0.89p pd=4.89u as=0.89p ps=4.89u w=2u l=0.28u
X85 a_20585_21760.t1 a_7027_22349.t5 VSS VSS nfet_03v3 ad=0.445p pd=2.89u as=0.445p ps=2.89u w=1u l=0.28u
X86 a_34200_21944# VSS cap_mim_2f0_m4m5_noshield c_width=89.88u c_length=89.88u
X87 a_149525_21760.t3 a_151087_22349# a_171220_35122# VDD pfet_03v3 ad=1.78p pd=8.89u as=1.78p ps=8.89u w=4u l=0.28u
X88 a_159605_30440# a_157925_30440# VSS VSS nfet_03v3 ad=0.445p pd=2.89u as=0.445p ps=2.89u w=1u l=0.28u
X89 a_151087_35509# a_152740_35122# VSS VSS nfet_03v3 ad=0.89p pd=4.89u as=0.89p ps=4.89u w=2u l=0.28u
X90 a_15987_2189# a_15987_2189# VSS VSS nfet_03v3 ad=0.445p pd=2.89u as=0.445p ps=2.89u w=1u l=0.28u
X91 a_133241_26660# ICP2.t0 a_131180_21760# VSS nfet_03v3 ad=0.89p pd=4.89u as=0.53p ps=2.53u w=2u l=0.28u
X92 a_5465_21760# a_5347_22349# VDD VDD pfet_03v3 ad=0.89p pd=4.89u as=0.89p ps=4.89u w=2u l=0.28u
X93 a_149525_30440.t1 a_149525_43880.t3 a_152740_43880# VSS nfet_03v3 ad=0.89p pd=4.89u as=0.89p ps=4.89u w=2u l=0.28u
X94 a_151087_22349# a_169685_39260# VSS VSS nfet_03v3 ad=0.89p pd=4.89u as=0.89p ps=4.89u w=2u l=0.28u
X95 a_3667_22349.t0 a_15545_21760# VSS VSS nfet_03v3 ad=0.445p pd=2.89u as=0.445p ps=2.89u w=1u l=0.28u
X96 a_138745_34982# ICP2.t2 VDD VDD pfet_03v3 ad=0.89p pd=4.89u as=0.89p ps=4.89u w=2u l=0.28u
X97 a_157925_30440# a_154565_30440# a_149380_35122# VSS nfet_03v3 ad=0.89p pd=4.89u as=0.89p ps=4.89u w=2u l=0.28u
X98 a_154447_26689.t0 a_149407_40129# VSS VSS nfet_03v3 ad=0.89p pd=4.89u as=0.89p ps=4.89u w=2u l=0.28u
X99 a_7027_22349.t0 a_3785_21760# VDD VDD pfet_03v3 ad=0.89p pd=4.89u as=0.89p ps=4.89u w=2u l=0.28u
X100 a_10360_43600# a_3667_35369# VSS VSS nfet_03v3 ad=1.335p pd=6.89u as=1.335p ps=6.89u w=3u l=0.28u
X101 a_149525_35122.t4 a_154565_30440# a_156100_30440# VDD pfet_03v3 ad=1.78p pd=8.89u as=1.78p ps=8.89u w=4u l=0.28u
X102 a_3785_39120# FB.t6 a_3640_39120# VSS nfet_03v3 ad=1.335p pd=6.89u as=1.335p ps=6.89u w=3u l=0.28u
X103 a_15400_26100# a_3785_21760# VSS VSS nfet_03v3 ad=0.89p pd=4.89u as=0.89p ps=4.89u w=2u l=0.28u
X104 a_123480_21999# a_121569_21999.t0 a_121569_21999.t0 VSS nfet_03v3 ad=1.78p pd=8.89u as=1.06p ps=4.53u w=4u l=1u
X105 a_162965_39260# a_161140_39260# VSS VSS nfet_03v3 ad=0.89p pd=4.89u as=0.89p ps=4.89u w=2u l=0.28u
X106 a_151205_39260# a_156245_39260# a_157780_39260# VDD pfet_03v3 ad=1.78p pd=8.89u as=1.78p ps=8.89u w=4u l=0.28u
X107 a_154447_40129# a_154420_35122# VSS VSS nfet_03v3 ad=0.89p pd=4.89u as=0.89p ps=4.89u w=2u l=0.28u
X108 a_34200_21944# VSS cap_mim_2f0_m4m5_noshield c_width=89.88u c_length=89.88u
X109 a_149525_30440.t4 a_151087_31029.t5 a_152740_43880# VDD pfet_03v3 ad=1.78p pd=8.89u as=1.78p ps=8.89u w=4u l=0.28u
X110 a_151087_35509# a_152740_35122# VDD VDD pfet_03v3 ad=1.78p pd=8.89u as=1.78p ps=8.89u w=4u l=0.28u
X111 a_161285_35122# a_156245_39260# a_157780_39260# VSS nfet_03v3 ad=0.445p pd=2.89u as=0.445p ps=2.89u w=1u l=0.28u
X112 VDD PB.t0 a_121869_26660# VDD pfet_03v3 ad=3.56p pd=16.89u as=2.12p ps=8.53u w=8u l=2u
X113 VSS NB.t4 a_123480_21999# VSS nfet_03v3 ad=2.12p pd=8.53u as=2.12p ps=8.53u w=8u l=2u
X114 a_159605_30440# a_157925_30440# VDD VDD pfet_03v3 ad=0.89p pd=4.89u as=0.89p ps=4.89u w=2u l=0.28u
X115 a_8825_43600# a_3785_43600# VDD VDD pfet_03v3 ad=0.89p pd=4.89u as=0.89p ps=4.89u w=2u l=0.28u
X116 a_154565_43880# a_151087_31029.t3 a_151060_30440# VSS nfet_03v3 ad=0.89p pd=4.89u as=0.89p ps=4.89u w=2u l=0.28u
X117 VCTRL.t1 VSS cap_mim_2f0_m4m5_noshield c_width=5u c_length=5u
X118 a_3785_21760# a_3667_22349.t2 VDD VDD pfet_03v3 ad=0.89p pd=4.89u as=0.89p ps=4.89u w=2u l=0.28u
X119 a_149525_43880.t1 a_5465_3840.t3 VDD VDD pfet_03v3 ad=1.78p pd=8.89u as=1.78p ps=8.89u w=4u l=0.28u
X120 a_12185_21760# a_5465_21760# VSS VSS nfet_03v3 ad=0.445p pd=2.89u as=0.445p ps=2.89u w=1u l=0.28u
X121 a_152885_39260# a_149407_40129# a_149380_39260# VSS nfet_03v3 ad=0.445p pd=2.89u as=0.445p ps=2.89u w=1u l=0.28u
X122 VSS NB.t0 a_129500_21760# VSS nfet_03v3 ad=3.56p pd=16.89u as=2.12p ps=8.53u w=8u l=2u
X123 a_169685_35122# a_169685_39260# a_171220_35122# VDD pfet_03v3 ad=0.89p pd=4.89u as=0.89p ps=4.89u w=2u l=0.28u
X124 a_121569_21999.t0 a_121569_21999.t0 a_123480_21999# VSS nfet_03v3 ad=1.06p pd=4.53u as=1.06p ps=4.53u w=4u l=1u
X125 a_152885_39260# a_151205_39260# VSS VSS nfet_03v3 ad=0.89p pd=4.89u as=0.89p ps=4.89u w=2u l=0.28u
X126 a_164645_35122# a_162965_39260# VDD VDD pfet_03v3 ad=1.78p pd=8.89u as=1.78p ps=8.89u w=4u l=0.28u
X127 a_149525_35122.t2 a_164645_30440# VSS VSS nfet_03v3 ad=0.89p pd=4.89u as=0.89p ps=4.89u w=2u l=0.28u
X128 a_3785_26100# a_3667_26689# a_3785_39120# VSS nfet_03v3 ad=1.335p pd=6.89u as=1.335p ps=6.89u w=3u l=0.28u
X129 a_3785_21760# a_7027_22349.t5 a_7000_39120# VSS nfet_03v3 ad=1.335p pd=6.89u as=1.335p ps=6.89u w=3u l=0.28u
X130 a_13865_30440# a_3667_26689# VDD VDD pfet_03v3 ad=0.89p pd=4.89u as=0.89p ps=4.89u w=2u l=0.28u
X131 a_122881_26660# PB.t9 VDD VDD pfet_03v3 ad=2.12p pd=8.53u as=2.12p ps=8.53u w=8u l=2u
X132 a_3667_5549# LO cap_mim_2f0_m4m5_noshield c_width=5u c_length=5u
X133 REFCK_O a_25205_4182# VDD VDD pfet_03v3 ad=0.89p pd=4.89u as=0.89p ps=4.89u w=2u l=0.28u
X134 a_152885_39260# a_151205_39260# VDD VDD pfet_03v3 ad=1.78p pd=8.89u as=1.78p ps=8.89u w=4u l=0.28u
X135 FB.t1 a_151060_21760# VDD VDD pfet_03v3 ad=1.78p pd=8.89u as=1.78p ps=8.89u w=4u l=0.28u
X136 a_154565_30440# a_149407_35509# VSS VSS nfet_03v3 ad=0.89p pd=4.89u as=0.89p ps=4.89u w=2u l=0.28u
X137 VDD PB.t14 a_121869_26660# VDD pfet_03v3 ad=2.12p pd=8.53u as=2.12p ps=8.53u w=8u l=2u
X138 a_5347_22349# a_3785_43600# a_3785_30440# VSS nfet_03v3 ad=0.89p pd=4.89u as=0.89p ps=4.89u w=2u l=0.28u
X139 a_5347_39849# a_3785_26100# VDD VDD pfet_03v3 ad=0.89p pd=4.89u as=0.89p ps=4.89u w=2u l=0.28u
X140 a_154565_43880# a_149525_43880.t6 a_151060_30440# VDD pfet_03v3 ad=1.78p pd=8.89u as=1.78p ps=8.89u w=4u l=0.28u
X141 a_149525_26100# a_149407_26689# VDD VDD pfet_03v3 ad=1.78p pd=8.89u as=1.78p ps=8.89u w=4u l=0.28u
X142 a_166325_35122# a_151205_39260# VSS VSS nfet_03v3 ad=0.445p pd=2.89u as=0.445p ps=2.89u w=1u l=0.28u
X143 VCTRL.t1 VSS cap_mim_2f0_m4m5_noshield c_width=5u c_length=5u
X144 a_5320_21760# a_7027_22349.t1 VSS VSS nfet_03v3 ad=0.89p pd=4.89u as=0.89p ps=4.89u w=2u l=0.28u
X145 a_122881_26660# a_138745_34982# a_121100_21999# VDD pfet_03v3 ad=2.67p pd=12.89u as=1.59p ps=6.53u w=6u l=0.28u
X146 a_151205_39260# a_154565_39260# a_157780_39260# VSS nfet_03v3 ad=0.89p pd=4.89u as=0.89p ps=4.89u w=2u l=0.28u
X147 a_149525_26100# a_149407_40129# a_149380_39260# VDD pfet_03v3 ad=1.78p pd=8.89u as=1.78p ps=8.89u w=4u l=0.28u
X148 a_3667_44329# a_3667_35369# a_22120_39120# VSS nfet_03v3 ad=0.89p pd=4.89u as=0.89p ps=4.89u w=2u l=0.28u
X149 a_34200_21944# VSS cap_mim_2f0_m4m5_noshield c_width=89.88u c_length=89.88u
X150 a_154565_35122.t4 a_154447_35509# a_154420_35122# VSS nfet_03v3 ad=0.445p pd=2.89u as=0.445p ps=2.89u w=1u l=0.28u
X151 a_13865_30440# a_5347_39849# a_13720_30440# VSS nfet_03v3 ad=0.89p pd=4.89u as=0.89p ps=4.89u w=2u l=0.28u
X152 a_169685_39260# a_151205_39260# VSS VSS nfet_03v3 ad=0.89p pd=4.89u as=0.89p ps=4.89u w=2u l=0.28u
X153 VCTRL.t1 VSS cap_mim_2f0_m4m5_noshield c_width=5u c_length=5u
X154 a_3640_43600# a_5347_44329# a_5320_43600# VSS nfet_03v3 ad=1.335p pd=6.89u as=1.335p ps=6.89u w=3u l=0.28u
X155 a_151205_26100# a_149407_40129# a_149407_26689# VDD pfet_03v3 ad=0.89p pd=4.89u as=0.89p ps=4.89u w=2u l=0.28u
X156 REFCK a_5347_44329# VSS ppolyf_u_1k r_width=2u r_length=2u
X157 a_156245_39260# a_154565_39260# VDD VDD pfet_03v3 ad=1.78p pd=8.89u as=1.78p ps=8.89u w=4u l=0.28u
X158 a_159605_30440# a_149407_35509# a_156100_30440# VDD pfet_03v3 ad=0.89p pd=4.89u as=0.89p ps=4.89u w=2u l=0.28u
X159 a_149525_26100# a_149407_26689# VSS VSS nfet_03v3 ad=0.89p pd=4.89u as=0.89p ps=4.89u w=2u l=0.28u
X160 a_34200_24066.t5 VSS cap_mim_2f0_m4m5_noshield c_width=51.67u c_length=51.67u
X161 a_3785_21760# a_3785_26100# VDD VDD pfet_03v3 ad=0.89p pd=4.89u as=0.89p ps=4.89u w=2u l=0.28u
X162 a_13720_43600# a_8825_43600# a_15400_43600# VSS nfet_03v3 ad=1.335p pd=6.89u as=1.335p ps=6.89u w=3u l=0.28u
X163 a_151087_31029.t0 a_149525_43880.t7 VDD VDD pfet_03v3 ad=1.78p pd=8.89u as=1.78p ps=8.89u w=4u l=0.28u
X164 a_149407_40129# a_154447_40129# VDD VDD pfet_03v3 ad=1.78p pd=8.89u as=1.78p ps=8.89u w=4u l=0.28u
X165 a_161285_35122# a_159605_39260# VSS VSS nfet_03v3 ad=0.445p pd=2.89u as=0.445p ps=2.89u w=1u l=0.28u
X166 a_151087_35509# a_152767_35509# a_154420_35122# VSS nfet_03v3 ad=0.89p pd=4.89u as=0.89p ps=4.89u w=2u l=0.28u
X167 a_3667_44329# a_3785_43600# VDD VDD pfet_03v3 ad=0.89p pd=4.89u as=0.89p ps=4.89u w=2u l=0.28u
X168 a_3667_26689# a_13865_30440# VDD VDD pfet_03v3 ad=0.89p pd=4.89u as=0.89p ps=4.89u w=2u l=0.28u
X169 VDD PB.t12 a_122881_26660# VDD pfet_03v3 ad=2.12p pd=8.53u as=2.12p ps=8.53u w=8u l=2u
X170 a_122881_26660# PB.t7 VDD VDD pfet_03v3 ad=2.12p pd=8.53u as=2.12p ps=8.53u w=8u l=2u
X171 a_3667_5549# LO cap_mim_2f0_m4m5_noshield c_width=5u c_length=5u
X172 a_149525_30440.t0 a_149525_43880.t5 a_151060_30440# VSS nfet_03v3 ad=0.445p pd=2.89u as=0.445p ps=2.89u w=1u l=0.28u
X173 a_151205_39260# a_149380_39260# VSS VSS nfet_03v3 ad=0.89p pd=4.89u as=0.89p ps=4.89u w=2u l=0.28u
X174 FB.t0 a_151060_21760# VSS VSS nfet_03v3 ad=0.89p pd=4.89u as=0.89p ps=4.89u w=2u l=0.28u
X175 a_154565_35122.t5 a_154447_35509# a_152740_35122# VSS nfet_03v3 ad=0.89p pd=4.89u as=0.89p ps=4.89u w=2u l=0.28u
X176 a_164645_30440# a_149380_35122# VDD VDD pfet_03v3 ad=1.78p pd=8.89u as=1.78p ps=8.89u w=4u l=0.28u
X177 a_8825_43600# a_3667_35369# VDD VDD pfet_03v3 ad=0.89p pd=4.89u as=0.89p ps=4.89u w=2u l=0.28u
X178 a_183125_39602# a_149525_43880.t2 a_152740_43880# VDD pfet_03v3 ad=0.89p pd=4.89u as=0.89p ps=4.89u w=2u l=0.28u
X179 a_122881_26660# PB.t3 VDD VDD pfet_03v3 ad=2.12p pd=8.53u as=2.12p ps=8.53u w=8u l=2u
X180 a_121100_21999# a_138745_34982# a_122881_26660# VDD pfet_03v3 ad=1.59p pd=6.53u as=2.67p ps=12.89u w=6u l=0.28u
X181 a_15545_21760# a_13865_21760# VSS VSS nfet_03v3 ad=0.445p pd=2.89u as=0.445p ps=2.89u w=1u l=0.28u
X182 a_13865_30440# a_5347_39849# VDD VDD pfet_03v3 ad=0.89p pd=4.89u as=0.89p ps=4.89u w=2u l=0.28u
X183 a_133241_26660# NB.t7 VSS VSS nfet_03v3 ad=2.12p pd=8.53u as=2.12p ps=8.53u w=8u l=2u
X184 a_151205_39260# a_149380_39260# VDD VDD pfet_03v3 ad=1.78p pd=8.89u as=1.78p ps=8.89u w=4u l=0.28u
X185 a_149407_40129# a_154447_40129# VSS VSS nfet_03v3 ad=0.89p pd=4.89u as=0.89p ps=4.89u w=2u l=0.28u
X186 a_7180_11606# a_3785_3840# VSS ppolyf_u_1k r_width=1u r_length=10u
X187 a_3785_26100# FB.t4 VDD VDD pfet_03v3 ad=0.89p pd=4.89u as=0.89p ps=4.89u w=2u l=0.28u
X188 a_7027_22349.t1 a_3667_26689# a_15400_26100# VSS nfet_03v3 ad=0.89p pd=4.89u as=0.89p ps=4.89u w=2u l=0.28u
X189 a_3785_3840# a_3667_5549# VDD VDD pfet_03v3 ad=3.56p pd=16.89u as=3.56p ps=16.89u w=8u l=0.28u
X190 a_8680_43600# a_5347_44329# a_10360_43600# VSS nfet_03v3 ad=1.335p pd=6.89u as=1.335p ps=6.89u w=3u l=0.28u
X191 a_149525_21760.t4 a_169685_39260# a_151060_21760# VSS nfet_03v3 ad=0.445p pd=2.89u as=0.445p ps=2.89u w=1u l=0.28u
X192 VDD a_152885_21760# FS VDD pfet_03v3 ad=0.795p pd=3.53u as=0.795p ps=3.53u w=3u l=0.28u
X193 a_157925_30440# a_156100_30440# VSS VSS nfet_03v3 ad=0.89p pd=4.89u as=0.89p ps=4.89u w=2u l=0.28u
X194 a_3667_5549# LO cap_mim_2f0_m4m5_noshield c_width=5u c_length=5u
X195 a_154565_35122.t1 a_152767_35509# a_152740_35122# VDD pfet_03v3 ad=1.78p pd=8.89u as=1.78p ps=8.89u w=4u l=0.28u
X196 a_121493_21789# a_18905_21760.t7 VSS VSS nfet_03v3 ad=0.445p pd=2.89u as=0.445p ps=2.89u w=1u l=0.28u
X197 a_169685_39260# a_151205_39260# VDD VDD pfet_03v3 ad=1.78p pd=8.89u as=1.78p ps=8.89u w=4u l=0.28u
X198 VDD a_152885_21760# FS VDD pfet_03v3 ad=1.335p pd=6.89u as=0.795p ps=3.53u w=3u l=0.28u
X199 a_3785_43600# a_3667_22349.t8 VDD VDD pfet_03v3 ad=0.89p pd=4.89u as=0.89p ps=4.89u w=2u l=0.28u
X200 a_18905_21760.t1 a_5347_22349# VDD VDD pfet_03v3 ad=0.89p pd=4.89u as=0.89p ps=4.89u w=2u l=0.28u
X201 a_138745_34982# ICP2.t3 VSS VSS nfet_03v3 ad=0.445p pd=2.89u as=0.445p ps=2.89u w=1u l=0.28u
X202 FS a_152885_21760# VDD VDD pfet_03v3 ad=0.795p pd=3.53u as=1.335p ps=6.89u w=3u l=0.28u
X203 VDD a_123769_21999# a_123769_21999# VDD pfet_03v3 ad=1.06p pd=4.53u as=1.06p ps=4.53u w=4u l=1u
X204 a_151205_26100# a_154447_26689.t4 a_149407_26689# VSS nfet_03v3 ad=0.445p pd=2.89u as=0.445p ps=2.89u w=1u l=0.28u
X205 a_3667_31029# a_3667_22349.t5 VDD VDD pfet_03v3 ad=0.89p pd=4.89u as=0.89p ps=4.89u w=2u l=0.28u
X206 a_151205_26100# a_149525_26100# VDD VDD pfet_03v3 ad=0.89p pd=4.89u as=0.89p ps=4.89u w=2u l=0.28u
X207 a_169685_35122# a_169567_35509# VDD VDD pfet_03v3 ad=0.89p pd=4.89u as=0.89p ps=4.89u w=2u l=0.28u
X208 a_164645_30440# a_149380_35122# VSS VSS nfet_03v3 ad=0.89p pd=4.89u as=0.89p ps=4.89u w=2u l=0.28u
X209 a_8680_26100# a_3667_22349.t2 VSS VSS nfet_03v3 ad=0.89p pd=4.89u as=0.89p ps=4.89u w=2u l=0.28u
X210 a_121869_26660# PB.t5 VDD VDD pfet_03v3 ad=2.12p pd=8.53u as=2.12p ps=8.53u w=8u l=2u
X211 a_131180_21760# ICP2.t1 a_133241_26660# VSS nfet_03v3 ad=0.53p pd=2.53u as=0.89p ps=4.89u w=2u l=0.28u
X212 a_8825_43600# a_3785_43600# a_8680_43600# VSS nfet_03v3 ad=1.335p pd=6.89u as=1.335p ps=6.89u w=3u l=0.28u
X213 a_154565_35122.t3 a_154447_40129# VDD VDD pfet_03v3 ad=1.78p pd=8.89u as=1.78p ps=8.89u w=4u l=0.28u
X214 VDD PB.t10 a_121869_26660# VDD pfet_03v3 ad=2.12p pd=8.53u as=2.12p ps=8.53u w=8u l=2u
X215 a_129500_21760# NB.t9 VSS VSS nfet_03v3 ad=2.12p pd=8.53u as=3.56p ps=16.89u w=8u l=2u
X216 a_169567_35509# a_169685_39260# a_151060_21760# VDD pfet_03v3 ad=1.78p pd=8.89u as=1.78p ps=8.89u w=4u l=0.28u
X217 a_149407_35509# a_149407_31029# VSS VSS nfet_03v3 ad=0.89p pd=4.89u as=0.89p ps=4.89u w=2u l=0.28u
X218 a_121869_26660# PB.t1 VDD VDD pfet_03v3 ad=2.12p pd=8.53u as=2.12p ps=8.53u w=8u l=2u
X219 VCTRL.t1 VSS cap_mim_2f0_m4m5_noshield c_width=5u c_length=5u
X220 a_25205_4182# a_5347_44329# VSS VSS nfet_03v3 ad=0.445p pd=2.89u as=0.445p ps=2.89u w=1u l=0.28u
X221 a_149525_35122.t3 a_164645_30440# VDD VDD pfet_03v3 ad=1.78p pd=8.89u as=1.78p ps=8.89u w=4u l=0.28u
X222 a_164645_35122# a_154565_39260# a_161140_39260# VSS nfet_03v3 ad=0.445p pd=2.89u as=0.445p ps=2.89u w=1u l=0.28u
X223 a_123480_21999# NB.t5 VSS VSS nfet_03v3 ad=2.12p pd=8.53u as=2.12p ps=8.53u w=8u l=2u
X224 a_34200_21944# VSS cap_mim_2f0_m4m5_noshield c_width=89.88u c_length=89.88u
X225 a_161285_35122# a_154565_39260# a_157780_39260# VDD pfet_03v3 ad=0.89p pd=4.89u as=0.89p ps=4.89u w=2u l=0.28u
X226 a_5347_44329# a_12627_2049# VDD VDD pfet_03v3 ad=0.89p pd=4.89u as=0.89p ps=4.89u w=2u l=0.28u
X227 a_149525_30440.t2 a_149407_31029# VSS VSS nfet_03v3 ad=0.89p pd=4.89u as=0.89p ps=4.89u w=2u l=0.28u
X228 a_151205_35122# a_154447_35509# a_152740_35122# VDD pfet_03v3 ad=0.89p pd=4.89u as=0.89p ps=4.89u w=2u l=0.28u
X229 VCTRL.t1 VSS cap_mim_2f0_m4m5_noshield c_width=5u c_length=5u
X230 a_13865_21760# a_12185_21760# VDD VDD pfet_03v3 ad=0.89p pd=4.89u as=0.89p ps=4.89u w=2u l=0.28u
X231 a_3785_43600# a_5347_44329# VDD VDD pfet_03v3 ad=0.89p pd=4.89u as=0.89p ps=4.89u w=2u l=0.28u
X232 a_151205_35122# a_152767_35509# a_152740_35122# VSS nfet_03v3 ad=0.445p pd=2.89u as=0.445p ps=2.89u w=1u l=0.28u
X233 a_5465_3840.t1 a_3785_3840# VDD VDD pfet_03v3 ad=3.56p pd=16.89u as=3.56p ps=16.89u w=8u l=0.28u
X234 a_3667_26689# a_3667_22349.t4 VDD VDD pfet_03v3 ad=0.89p pd=4.89u as=0.89p ps=4.89u w=2u l=0.28u
X235 a_159605_30440# a_154565_30440# a_156100_30440# VSS nfet_03v3 ad=0.445p pd=2.89u as=0.445p ps=2.89u w=1u l=0.28u
X236 a_7180_11606# a_3667_5549# VSS ppolyf_u_1k r_width=1u r_length=10u
X237 a_3785_43600# a_3667_44329# a_3640_43600# VSS nfet_03v3 ad=1.335p pd=6.89u as=1.335p ps=6.89u w=3u l=0.28u
X238 a_149525_35122.t1 a_149407_35509# a_149380_35122# VSS nfet_03v3 ad=0.445p pd=2.89u as=0.445p ps=2.89u w=1u l=0.28u
X239 a_149525_43880.t0 a_5465_3840.t2 VSS VSS nfet_03v3 ad=0.89p pd=4.89u as=0.89p ps=4.89u w=2u l=0.28u
X240 a_5347_39849# a_3785_26100# a_8680_26100# VSS nfet_03v3 ad=0.89p pd=4.89u as=0.89p ps=4.89u w=2u l=0.28u
X241 VCTRL.t1 VSS cap_mim_2f0_m4m5_noshield c_width=5u c_length=5u
X242 a_151087_22349# a_169685_39260# VDD VDD pfet_03v3 ad=1.78p pd=8.89u as=1.78p ps=8.89u w=4u l=0.28u
X243 a_164645_35122# a_156245_39260# a_161140_39260# VDD pfet_03v3 ad=0.89p pd=4.89u as=0.89p ps=4.89u w=2u l=0.28u
X244 FS a_152885_21760# VDD VDD pfet_03v3 ad=0.795p pd=3.53u as=0.795p ps=3.53u w=3u l=0.28u
X245 a_149525_35122.t0 a_149407_35509# a_156100_30440# VSS nfet_03v3 ad=0.89p pd=4.89u as=0.89p ps=4.89u w=2u l=0.28u
X246 a_166325_35122# a_149407_40129# a_149407_26689# VSS nfet_03v3 ad=0.89p pd=4.89u as=0.89p ps=4.89u w=2u l=0.28u
X247 a_20585_21760.t0 a_7027_22349.t3 VDD VDD pfet_03v3 ad=0.89p pd=4.89u as=0.89p ps=4.89u w=2u l=0.28u
X248 a_122881_26660# PB.t13 VDD VDD pfet_03v3 ad=2.12p pd=8.53u as=2.12p ps=8.53u w=8u l=2u
X249 VDD PB.t8 a_122881_26660# VDD pfet_03v3 ad=2.12p pd=8.53u as=2.12p ps=8.53u w=8u l=2u
X250 a_34200_24066.t4 a_7027_22349.t4 a_129500_21760# VSS nfet_03v3 ad=0.89p pd=4.89u as=0.89p ps=4.89u w=2u l=0.28u
X251 VCTRL.t1 VSS cap_mim_2f0_m4m5_noshield c_width=5u c_length=5u
X252 REFCK_O a_25205_4182# VSS VSS nfet_03v3 ad=0.445p pd=2.89u as=0.445p ps=2.89u w=1u l=0.28u
X253 a_169567_35509# a_171220_35122# VSS VSS nfet_03v3 ad=0.89p pd=4.89u as=0.89p ps=4.89u w=2u l=0.28u
X254 a_123480_21999# a_34200_24066.t1 a_123769_21999# VSS nfet_03v3 ad=1.06p pd=4.53u as=1.06p ps=4.53u w=4u l=1u
X255 a_34200_24066.t2 VCTRL.t0 VSS ppolyf_u_1k r_width=2u r_length=4u
X256 a_3667_22349.t1 a_15545_21760# VDD VDD pfet_03v3 ad=0.89p pd=4.89u as=0.89p ps=4.89u w=2u l=0.28u
X257 a_3667_44329# a_3667_35369# VDD VDD pfet_03v3 ad=0.89p pd=4.89u as=0.89p ps=4.89u w=2u l=0.28u
X258 VCTRL.t1 VSS cap_mim_2f0_m4m5_noshield c_width=5u c_length=5u
X259 a_121493_21789# a_18905_21760.t6 VDD VDD pfet_03v3 ad=0.89p pd=4.89u as=0.89p ps=4.89u w=2u l=0.28u
X260 a_151205_26100# a_149525_26100# VSS VSS nfet_03v3 ad=0.445p pd=2.89u as=0.445p ps=2.89u w=1u l=0.28u
X261 a_5347_22349# a_3785_43600# VDD VDD pfet_03v3 ad=0.89p pd=4.89u as=0.89p ps=4.89u w=2u l=0.28u
X262 a_13720_30440# a_3667_26689# VSS VSS nfet_03v3 ad=0.89p pd=4.89u as=0.89p ps=4.89u w=2u l=0.28u
X263 a_159605_39260# a_156245_39260# a_161140_39260# VSS nfet_03v3 ad=0.89p pd=4.89u as=0.89p ps=4.89u w=2u l=0.28u
X264 a_183125_39602# a_151087_31029.t4 a_152740_43880# VSS nfet_03v3 ad=0.445p pd=2.89u as=0.445p ps=2.89u w=1u l=0.28u
X265 a_5347_44329# a_14307_2049# VSS VSS nfet_03v3 ad=0.89p pd=4.89u as=0.89p ps=4.89u w=2u l=0.28u
X266 a_133241_26660# NB.t3 VSS VSS nfet_03v3 ad=2.12p pd=8.53u as=2.12p ps=8.53u w=8u l=2u
X267 a_3667_5549# LO cap_mim_2f0_m4m5_noshield c_width=5u c_length=5u
X268 VCTRL.t1 VSS cap_mim_2f0_m4m5_noshield c_width=5u c_length=5u
X269 a_157925_30440# a_149407_35509# a_149380_35122# VDD pfet_03v3 ad=1.78p pd=8.89u as=1.78p ps=8.89u w=4u l=0.28u
X270 a_183125_39602# a_154565_43880# VDD VDD pfet_03v3 ad=0.89p pd=4.89u as=0.89p ps=4.89u w=2u l=0.28u
X271 VCTRL.t1 VSS cap_mim_2f0_m4m5_noshield c_width=5u c_length=5u
X272 a_5320_43600# a_3667_22349.t12 VSS VSS nfet_03v3 ad=1.335p pd=6.89u as=1.335p ps=6.89u w=3u l=0.28u
X273 a_3785_26100# a_3667_26689# VDD VDD pfet_03v3 ad=0.89p pd=4.89u as=0.89p ps=4.89u w=2u l=0.28u
X274 a_3667_5549# LO cap_mim_2f0_m4m5_noshield c_width=5u c_length=5u
X275 a_121569_21999.t4 VSS cap_mim_2f0_m4m5_noshield c_width=32.01u c_length=32.01u
X276 a_154565_35122.t0 a_152767_35509# a_154420_35122# VDD pfet_03v3 ad=0.89p pd=4.89u as=0.89p ps=4.89u w=2u l=0.28u
X277 a_149525_30440.t2 a_151087_31029.t2 a_151060_30440# VDD pfet_03v3 ad=0.89p pd=4.89u as=0.89p ps=4.89u w=2u l=0.28u
X278 a_12185_21760# a_5465_21760# VDD VDD pfet_03v3 ad=0.89p pd=4.89u as=0.89p ps=4.89u w=2u l=0.28u
X279 a_20440_43600# a_3667_22349.t10 VSS VSS nfet_03v3 ad=1.335p pd=6.89u as=1.335p ps=6.89u w=3u l=0.28u
X280 a_152767_35509# a_154447_35509# VDD VDD pfet_03v3 ad=1.78p pd=8.89u as=1.78p ps=8.89u w=4u l=0.28u
X281 a_3785_43600# a_3667_44329# VDD VDD pfet_03v3 ad=0.89p pd=4.89u as=0.89p ps=4.89u w=2u l=0.28u
X282 a_151205_35122# a_151087_35509# VSS VSS nfet_03v3 ad=0.445p pd=2.89u as=0.445p ps=2.89u w=1u l=0.28u
X283 a_151087_31029.t1 a_149525_43880.t4 VSS VSS nfet_03v3 ad=0.89p pd=4.89u as=0.89p ps=4.89u w=2u l=0.28u
X284 a_121869_26660# PB.t15 VDD VDD pfet_03v3 ad=2.12p pd=8.53u as=3.56p ps=16.89u w=8u l=2u
X285 a_5465_3840.t0 a_3785_3840# VSS VSS nfet_03v3 ad=1.78p pd=8.89u as=1.78p ps=8.89u w=4u l=0.28u
X286 VSS a_152885_21760# FS VSS nfet_03v3 ad=1.335p pd=6.89u as=0.795p ps=3.53u w=3u l=0.28u
X287 VCTRL.t1 VSS cap_mim_2f0_m4m5_noshield c_width=5u c_length=5u
X288 a_166325_35122# a_162965_39260# a_166325_39260# VDD pfet_03v3 ad=1.78p pd=8.89u as=1.78p ps=8.89u w=4u l=0.28u
X289 a_154447_35509# a_164645_30440# VSS VSS nfet_03v3 ad=0.89p pd=4.89u as=0.89p ps=4.89u w=2u l=0.28u
X290 VDD PB.t6 a_122881_26660# VDD pfet_03v3 ad=2.12p pd=8.53u as=2.12p ps=8.53u w=8u l=2u
X291 a_154565_30440# a_149407_35509# VDD VDD pfet_03v3 ad=1.78p pd=8.89u as=1.78p ps=8.89u w=4u l=0.28u
X292 a_166325_35122# a_154447_26689.t5 a_149407_26689# VDD pfet_03v3 ad=1.78p pd=8.89u as=1.78p ps=8.89u w=4u l=0.28u
X293 a_22120_39120# a_3785_43600# VSS VSS nfet_03v3 ad=0.89p pd=4.89u as=0.89p ps=4.89u w=2u l=0.28u
X294 a_121869_26660# PB.t11 VDD VDD pfet_03v3 ad=2.12p pd=8.53u as=2.12p ps=8.53u w=8u l=2u
X295 a_3667_31029# a_8825_43600# VDD VDD pfet_03v3 ad=0.89p pd=4.89u as=0.89p ps=4.89u w=2u l=0.28u
X296 a_152885_21760# FB.t2 VSS VSS nfet_03v3 ad=0.89p pd=4.89u as=0.89p ps=4.89u w=2u l=0.28u
X297 a_3667_35369# a_3667_22349.t6 VDD VDD pfet_03v3 ad=0.89p pd=4.89u as=0.89p ps=4.89u w=2u l=0.28u
X298 a_25205_4182# a_5347_44329# VDD VDD pfet_03v3 ad=0.89p pd=4.89u as=0.89p ps=4.89u w=2u l=0.28u
X299 a_149525_30440.t3 a_149407_31029# VDD VDD pfet_03v3 ad=1.78p pd=8.89u as=1.78p ps=8.89u w=4u l=0.28u
X300 a_154447_40129# a_154420_35122# VDD VDD pfet_03v3 ad=1.78p pd=8.89u as=1.78p ps=8.89u w=4u l=0.28u
X301 a_3785_26100# a_5347_39849# VDD VDD pfet_03v3 ad=0.89p pd=4.89u as=0.89p ps=4.89u w=2u l=0.28u
X302 a_121569_21999.t0 a_20585_21760.t2 a_131180_21760# VSS nfet_03v3 ad=0.89p pd=4.89u as=0.89p ps=4.89u w=2u l=0.28u
X303 a_169685_35122# a_169567_35509# VSS VSS nfet_03v3 ad=0.445p pd=2.89u as=0.445p ps=2.89u w=1u l=0.28u
X304 VCTRL.t1 VSS cap_mim_2f0_m4m5_noshield c_width=5u c_length=5u
X305 a_123769_21999# a_123769_21999# VDD VDD pfet_03v3 ad=1.06p pd=4.53u as=1.78p ps=8.89u w=4u l=1u
X306 a_169567_35509# a_171220_35122# VDD VDD pfet_03v3 ad=1.78p pd=8.89u as=1.78p ps=8.89u w=4u l=0.28u
X307 FS a_152885_21760# VSS VSS nfet_03v3 ad=0.795p pd=3.53u as=1.335p ps=6.89u w=3u l=0.28u
X308 a_149525_21760.t0 FB.t3 VSS VSS nfet_03v3 ad=0.89p pd=4.89u as=0.89p ps=4.89u w=2u l=0.28u
C0 VDD a_162965_39260# 3.22302f
C1 REFCK_O a_25205_4182# 0.12775f
C2 a_152885_21760# a_151205_39260# 0.03791f
C3 a_186924_34720# VDD 0.33892f
C4 a_158074_39200# a_157780_39260# 0.01533f
C5 a_152624_43820# a_152740_43880# 0.0425f
C6 a_121100_21999# a_123480_21999# 0.25089f
C7 a_166474_43820# a_166064_43820# 0.0129f
C8 a_3667_31029# a_5347_22349# 0.28329f
C9 a_157925_30440# a_149407_35509# 0.6527f
C10 a_156100_30440# a_156245_39260# 0.03234f
C11 a_8825_43600# FB 0.14356f
C12 a_133241_26660# ICP2 0.09557f
C13 a_176284_34720# FS 0.01084f
C14 a_149407_35509# a_154565_30440# 0.39046f
C15 a_177824_43820# VDD 0.63502f
C16 a_8825_43600# a_5347_44329# 0.13268f
C17 VDD a_166064_39200# 0.63479f
C18 a_154565_39260# a_159605_39260# 1.15927f
C19 a_129608_26600# a_121100_21999# 0.01292f
C20 a_149407_26689# a_151087_22349# 0.07634f
C21 a_149407_35509# a_152767_35509# 0.04007f
C22 a_3667_31029# a_14014_43540# 0.02878f
C23 a_166474_43820# VDD 0.60458f
C24 a_151087_35509# a_154565_39260# 0.03494f
C25 a_123769_21999# VDD 3.43186f
C26 a_166474_26040# a_159605_39260# 0.02665f
C27 a_5204_34720# a_3667_44329# 0.01053f
C28 a_3785_26100# a_8680_39120# 0.04198f
C29 VCTRL a_149380_39260# 0.03341f
C30 a_171220_35122# a_157925_30440# 0.09277f
C31 a_151205_35122# a_149407_40129# 0.09994f
C32 a_171514_35062# a_169685_35122# 0.01407f
C33 a_159605_30440# a_152740_43880# 0.04339f
C34 a_156100_30440# a_149407_35509# 0.55571f
C35 a_151087_35509# FS 0.12321f
C36 a_159344_43820# a_149407_31029# 0.01044f
C37 a_149407_26689# a_152885_21760# 0.03865f
C38 a_171220_35122# a_154565_30440# 0.0103f
C39 VDD a_174874_43820# 0.60275f
C40 a_27034_3780# VDD 0.35048f
C41 a_3667_31029# a_13720_43600# 0.23634f
C42 a_161285_35122# a_154565_39260# 0.09626f
C43 a_171220_35122# a_152767_35509# 0.13478f
C44 REFCK_O FB 1.07562f
C45 a_154447_40129# a_154447_35509# 0.39219f
C46 a_3785_43600# a_3667_31029# 0.09509f
C47 a_169424_43820# a_164645_30440# 0.01244f
C48 a_156245_39260# a_151205_39260# 2.76769f
C49 a_151087_35509# a_152885_39260# 0.04126f
C50 a_185654_34720# VDD 0.34727f
C51 a_158074_39200# a_157664_39200# 0.0129f
C52 REFCK a_3667_5549# 0.03442f
C53 a_129384_21700# a_129500_21760# 0.01998f
C54 a_121100_21999# a_133241_26660# 0.0947f
C55 a_157925_30440# a_166064_43820# 0.02068f
C56 a_156100_30440# a_171220_35122# 0.09098f
C57 a_187334_34720# VDD 0.34168f
C58 a_13604_43540# a_13720_43600# 0.02888f
C59 a_154565_39260# a_162965_39260# 0.07592f
C60 a_13865_30440# FB 0.09689f
C61 a_159754_26040# VDD 0.34201f
C62 a_171104_43820# a_171514_43820# 0.0129f
C63 a_149407_35509# a_162704_43820# 0.01106f
C64 a_154447_40129# a_157780_39260# 0.2553f
C65 a_8680_43600# a_5347_44329# 0.19847f
C66 VDD a_164794_39200# 0.59946f
C67 a_8974_39060# a_7000_39120# 0.02878f
C68 a_167744_43820# a_149380_35122# 0.05819f
C69 a_152740_35122# a_152740_43880# 0.04076f
C70 a_149407_26689# a_187904_43820# 0.05401f
C71 a_3640_39120# a_5347_39849# 0.05564f
C72 a_157925_30440# VDD 3.00676f
C73 a_149407_35509# a_151205_39260# 0.04223f
C74 a_154447_35509# a_151060_21760# 0.06726f
C75 a_3934_34720# a_3667_44329# 0.02648f
C76 a_152740_43880# a_149407_31029# 0.09496f
C77 a_151205_35122# a_164645_35122# 0.02484f
C78 a_156100_30440# a_166064_43820# 0.01103f
C79 a_166325_35122# a_171220_35122# 0.05423f
C80 a_149407_26689# a_156245_39260# 0.03001f
C81 VDD a_154565_30440# 7.26317f
C82 a_158074_43820# a_149407_31029# 0.04517f
C83 a_149407_40129# a_149674_39200# 0.01467f
C84 a_10244_43540# a_5347_44329# 0.01229f
C85 VDD a_152767_35509# 5.91292f
C86 a_3667_31029# a_13604_43540# 0.01659f
C87 a_157780_39260# a_151060_21760# 0.07014f
C88 a_171104_30380# a_154447_35509# 0.01037f
C89 a_149407_40129# a_169685_39260# 0.05437f
C90 a_156100_30440# VDD 2.838f
C91 REFCK_O VCTRL 0.04851f
C92 a_13865_21760# a_14014_39402# 0.01732f
C93 a_149407_26689# a_149407_35509# 0.03976f
C94 a_179914_39200# VDD 0.60254f
C95 a_20324_21700# VDD 0.36665f
C96 a_184544_30380# a_154420_35122# 0.02457f
C97 a_159344_26040# VDD 0.33901f
C98 a_3667_35369# a_5347_39849# 0.04359f
C99 a_154447_35509# a_154420_35122# 0.10318f
C100 a_3785_39120# a_15400_43600# 0.08588f
C101 a_8680_39120# a_7000_39120# 0.2601f
C102 a_152885_21760# a_153034_21700# 0.02481f
C103 a_3667_35369# a_3785_30440# 0.01076f
C104 a_159605_30440# a_169567_35509# 0.04031f
C105 a_3640_39120# a_3934_39060# 0.01038f
C106 a_153034_43820# VDD 0.58546f
C107 a_13865_30440# a_18760_43600# 0.03905f
C108 a_5465_21760# a_5347_39849# 0.04835f
C109 a_151087_35509# a_149525_26100# 0.10206f
C110 a_166325_35122# VDD 2.12261f
C111 a_177824_39200# a_151060_21760# 0.01279f
C112 a_169685_35122# a_154447_35509# 0.04247f
C113 a_149407_26689# a_171220_35122# 0.03901f
C114 VDD a_162704_43820# 0.63502f
C115 a_157780_39260# a_154420_35122# 0.04664f
C116 a_166325_35122# a_189994_30380# 0.01988f
C117 a_149407_40129# a_149380_39260# 0.17603f
C118 a_158074_43820# a_157664_43820# 0.0129f
C119 a_157925_30440# a_154565_39260# 0.03124f
C120 a_5465_21760# a_3785_30440# 0.03667f
C121 a_151354_39200# a_149380_39260# 0.0117f
C122 a_3785_26100# a_23684_43540# 0.01051f
C123 a_129500_21760# ICP2 0.14327f
C124 a_154565_39260# a_154565_30440# 0.07374f
C125 a_159605_30440# a_161140_39260# 0.03665f
C126 a_151205_39260# VDD 4.53641f
C127 a_152885_39260# a_159754_26040# 0.02195f
C128 VDD a_150944_43820# 0.63738f
C129 a_159605_30440# a_152740_35122# 0.06724f
C130 a_154565_39260# a_152767_35509# 0.03522f
C131 a_184544_43820# VDD 0.63502f
C132 a_149380_35122# a_159605_39260# 0.03127f
C133 a_151087_22349# FB 0.15604f
C134 a_159605_30440# a_149407_31029# 0.03124f
C135 FS a_152767_35509# 0.06609f
C136 a_3785_39120# a_10360_43600# 0.0737f
C137 a_157925_30440# a_152885_39260# 0.11968f
C138 a_156100_30440# a_154565_39260# 0.11981f
C139 a_179504_39200# VDD 0.6348f
C140 a_169567_35509# a_152740_35122# 0.08899f
C141 a_19054_21700# VDD 0.3476f
C142 a_151087_35509# a_149380_35122# 0.04375f
C143 a_161434_30380# a_159605_30440# 0.02148f
C144 a_154447_40129# a_154714_39200# 0.01104f
C145 a_179504_43820# VDD 0.5834f
C146 VDD a_149264_43820# 0.63738f
C147 a_12185_21760# a_5347_39849# 0.04223f
C148 a_152885_39260# a_154565_30440# 0.02915f
C149 a_169567_35509# a_149407_31029# 0.0275f
C150 a_26624_3780# VDD 0.36295f
C151 a_152885_21760# FB 0.40239f
C152 a_152885_39260# a_152767_35509# 0.04007f
C153 a_12185_21760# a_3785_30440# 0.03791f
C154 a_17080_34780# a_3785_30440# 0.03671f
C155 a_167744_39200# a_168154_39200# 0.0129f
C156 a_161140_39260# a_161434_39200# 0.01885f
C157 a_149407_26689# VDD 3.88356f
C158 a_161285_35122# a_149380_35122# 0.03501f
C159 a_152740_35122# a_161140_39260# 1.40651f
C160 a_156100_30440# a_152885_39260# 0.03791f
C161 a_5347_22349# a_5347_39849# 0.07708f
C162 a_129500_21760# a_121100_21999# 1.73622f
C163 a_161140_39260# a_149407_31029# 0.02244f
C164 a_3785_39120# a_23684_43540# 0.03432f
C165 a_150944_39200# VDD 0.63738f
C166 a_152740_35122# a_149407_31029# 0.05736f
C167 a_5347_22349# a_3785_30440# 0.0995f
C168 a_149380_35122# a_162965_39260# 0.0418f
C169 a_152885_39260# a_159344_26040# 0.01055f
C170 VDD a_149674_43820# 0.60202f
C171 a_154565_39260# a_151205_39260# 1.30399f
C172 a_183274_43820# VDD 0.60458f
C173 PB VDD 25.3199f
C174 a_5614_30380# a_5347_22349# 0.02332f
C175 a_151087_22349# VCTRL 0.0303f
C176 a_152740_43880# a_154565_43880# 6.83615f
C177 a_178234_43820# VDD 0.60458f
C178 a_156245_39260# FB 0.04285f
C179 a_151205_35122# a_154447_40129# 0.42754f
C180 a_161285_35122# a_168154_26040# 0.02332f
C181 a_161024_39200# a_161140_39260# 0.04522f
C182 a_3785_43600# a_5347_39849# 0.04223f
C183 a_34874_3780# REFCK_O 0.0245f
C184 a_152885_39260# a_151205_39260# 0.23209f
C185 a_161024_39200# a_161434_39200# 0.0129f
C186 VDD a_169834_43820# 0.60458f
C187 a_152885_21760# VCTRL 0.0361f
C188 a_20324_43540# a_20440_43600# 0.02865f
C189 a_149407_26689# a_189584_30380# 0.02378f
C190 a_161024_43820# a_161434_43820# 0.0129f
C191 a_3785_43600# a_3785_30440# 1.51366f
C192 a_131280_26600# a_121100_21999# 0.01116f
C193 a_157925_30440# a_149525_26100# 0.05232f
C194 a_5614_34720# a_3667_44329# 0.021f
C195 a_176144_43820# a_152740_35122# 0.05733f
C196 a_159605_39260# a_159754_39200# 0.04661f
C197 a_149407_26689# a_154565_39260# 0.03791f
C198 a_167744_26040# a_159605_39260# 0.01531f
C199 a_149407_35509# FB 0.04359f
C200 a_149525_26100# a_154565_30440# 0.10759f
C201 a_149407_26689# FS 0.03557f
C202 a_3785_26100# PB 0.08174f
C203 a_151205_35122# a_151060_21760# 0.21788f
C204 a_157664_43820# a_149407_31029# 0.01692f
C205 a_151354_30380# VDD 0.33915f
C206 a_152767_35509# a_149525_26100# 0.10231f
C207 a_3667_31029# a_5347_39849# 0.03791f
C208 a_121869_26660# a_140864_26839# 0.04522f
C209 a_121493_21789# a_131054_34922# 0.01511f
C210 a_20440_43600# a_22004_43540# 0.01133f
C211 a_3667_31029# a_3785_30440# 0.09899f
C212 a_149407_26689# a_152885_39260# 0.03124f
C213 a_20734_21700# VDD 0.3476f
C214 a_156100_30440# a_149525_26100# 0.09093f
C215 a_171220_35122# FB 0.04359f
C216 a_3667_5549# a_8000_9484# 0.01127f
C217 a_25205_4182# VDD 1.39276f
C218 a_151060_30440# a_149407_35509# 0.06094f
C219 a_157925_30440# a_149380_35122# 0.63092f
C220 a_22120_39120# a_3667_44329# 0.18791f
C221 a_5320_43600# a_6884_43540# 0.01082f
C222 NB ICP2 0.15417f
C223 a_156245_39260# VCTRL 0.02805f
C224 a_34464_3780# REFCK_O 0.01045f
C225 VDD a_164645_30440# 3.52985f
C226 a_149380_35122# a_154565_30440# 0.2192f
C227 a_141760_26839# VDD 0.58135f
C228 a_3785_43600# a_23684_34720# 0.01157f
C229 VDD a_176144_39200# 0.58253f
C230 a_161024_43820# a_149407_35509# 0.02092f
C231 a_149380_35122# a_152767_35509# 0.04015f
C232 a_151205_35122# a_154420_35122# 3.94744f
C233 PB a_3785_21760# 0.03851f
C234 a_161285_35122# a_161434_35062# 0.01386f
C235 a_156394_43820# VDD 0.58373f
C236 a_154447_40129# a_169685_39260# 0.03804f
C237 a_166325_35122# a_149525_26100# 0.06319f
C238 a_17374_21700# VDD 0.35048f
C239 a_8680_39120# a_8974_39060# 0.01363f
C240 a_159605_30440# a_154565_43880# 0.03042f
C241 a_151087_35509# a_159605_39260# 0.05735f
C242 a_156100_30440# a_149380_35122# 0.1431f
C243 a_158074_35062# a_151205_26100# 0.01149f
C244 VDD a_13604_26040# 0.3627f
C245 a_150944_30380# VDD 0.34103f
C246 a_149407_35509# VCTRL 0.63094f
C247 a_15844_1742# a_15987_2189# 0.01029f
C248 a_169685_35122# a_151205_35122# 0.02927f
C249 a_151205_39260# a_149525_26100# 0.35995f
C250 a_16964_26040# a_3785_21760# 0.01218f
C251 a_20440_43600# a_20734_43540# 0.01363f
C252 VDD FB 11.3884f
C253 a_161285_35122# a_159605_39260# 0.49214f
C254 a_154447_40129# a_182864_43820# 0.01089f
C255 a_183125_39602# VDD 0.99491f
C256 NB a_121100_21999# 0.06751f
C257 a_169685_39260# a_151060_21760# 0.19351f
C258 a_176554_26040# a_164645_35122# 0.01988f
C259 a_149407_40129# a_151087_22349# 0.04562f
C260 a_157925_30440# a_167744_43820# 0.01705f
C261 a_162965_39260# a_163114_39200# 0.05057f
C262 a_22004_39060# a_3667_44329# 0.01202f
C263 a_5347_44329# VDD 5.22531f
C264 a_166325_35122# a_149380_35122# 0.03849f
C265 a_171220_35122# VCTRL 0.02805f
C266 a_151354_21700# VDD 0.33915f
C267 a_152740_35122# a_154565_43880# 0.04261f
C268 a_183274_30380# a_154447_40129# 0.01133f
C269 a_15545_21760# PB 0.04359f
C270 VDD a_174874_39200# 0.60202f
C271 a_152885_21760# a_149407_40129# 0.15689f
C272 a_151087_35509# a_162965_39260# 0.05496f
C273 a_129608_26600# a_123480_21999# 0.01108f
C274 a_154565_39260# a_164645_30440# 0.03064f
C275 a_151060_30440# VDD 3.91865f
C276 a_154565_43880# a_149407_31029# 0.12821f
C277 a_5204_30380# VDD 0.3648f
C278 a_149380_35122# a_151205_39260# 0.05692f
C279 a_149407_26689# a_149525_26100# 0.69816f
C280 a_16964_21700# VDD 0.36295f
C281 a_24094_30380# VDD 0.34888f
C282 a_151205_26100# a_149407_35509# 0.36528f
C283 a_149380_39260# a_151060_21760# 0.0588f
C284 a_13865_21760# PB 0.03998f
C285 a_152740_43880# a_154447_35509# 0.03556f
C286 a_177824_43820# a_151087_35509# 0.01172f
C287 a_161024_43820# VDD 0.63279f
C288 a_3785_26100# FB 0.16013f
C289 a_161285_35122# a_162965_39260# 1.2541f
C290 a_169685_39260# a_154420_35122# 0.03248f
C291 a_3785_26100# a_5347_44329# 0.0411f
C292 a_154447_40129# a_181594_43820# 0.04741f
C293 a_150944_26040# VDD 0.36391f
C294 a_121493_21789# a_123769_21999# 0.04937f
C295 a_151087_22349# a_164645_35122# 0.04791f
C296 a_133241_26660# a_123480_21999# 0.19719f
C297 VCTRL VDD 4.54738f
C298 a_7294_30380# a_5347_22349# 0.02373f
C299 a_154565_39260# FB 0.03676f
C300 a_177180_34720# VDD 0.50021f
C301 a_123769_21999# a_124836_21939# 0.03188f
C302 a_149407_26689# a_149380_35122# 0.88309f
C303 a_169685_35122# a_169685_39260# 0.55561f
C304 a_11924_30380# VDD 0.36341f
C305 VDD a_166474_39200# 0.60019f
C306 a_150944_21700# VDD 0.34103f
C307 a_178234_30380# VDD 0.34107f
C308 FB FS 0.04367f
C309 a_149407_40129# a_156245_39260# 0.05935f
C310 a_182864_30380# a_154447_40129# 0.01142f
C311 a_152885_21760# a_164645_35122# 0.04359f
C312 NB a_5465_21760# 0.0418f
C313 a_164794_26040# a_151205_39260# 0.02176f
C314 a_122881_26660# VDD 3.75996f
C315 a_149380_39260# a_154420_35122# 0.04417f
C316 a_3785_3840# REFCK 0.09179f
C317 a_15694_21700# VDD 0.3476f
C318 a_151205_35122# a_176554_30380# 0.02332f
C319 PB a_3667_26689# 0.04359f
C320 a_156394_43820# a_155984_43820# 0.0129f
C321 FB a_3785_21760# 0.08137f
C322 a_23684_30380# VDD 0.3627f
C323 a_152885_39260# FB 0.04359f
C324 a_174464_43820# VDD 0.63502f
C325 a_159754_43820# VDD 0.60458f
C326 a_3785_39120# FB 0.22347f
C327 a_5347_44329# a_3785_21760# 0.0411f
C328 a_157925_30440# a_159605_39260# 0.03791f
C329 a_174874_30380# a_151087_35509# 0.02332f
C330 a_15400_26100# a_3785_21760# 0.30974f
C331 a_149407_40129# a_149407_35509# 0.21867f
C332 a_15400_26100# a_17374_26040# 0.01988f
C333 a_157925_30440# a_151087_35509# 0.07245f
C334 a_159605_39260# a_154565_30440# 0.03124f
C335 a_181184_43820# a_181594_43820# 0.0129f
C336 a_3785_39120# a_5347_44329# 0.04377f
C337 a_151205_26100# VDD 1.45052f
C338 a_121493_21789# a_123220_21939# 0.01269f
C339 a_3667_35369# a_22120_39120# 0.02905f
C340 a_159605_39260# a_152767_35509# 0.04203f
C341 a_151087_35509# a_154565_30440# 0.07128f
C342 NB a_12185_21760# 0.04359f
C343 a_10654_30380# VDD 0.34827f
C344 a_11924_34720# VDD 0.36272f
C345 VDD a_166325_39260# 0.89075f
C346 a_151087_35509# a_152767_35509# 1.28239f
C347 a_184954_43820# VDD 0.60458f
C348 a_161285_35122# a_157925_30440# 0.02538f
C349 a_152624_39200# VDD 0.63738f
C350 a_177824_30380# VDD 0.33892f
C351 a_156245_39260# a_164645_35122# 0.07021f
C352 a_154565_39260# VCTRL 0.0303f
C353 a_156100_30440# a_159605_39260# 0.03791f
C354 a_149407_40129# a_171220_35122# 0.03129f
C355 a_159605_30440# a_154447_35509# 0.07535f
C356 a_164384_26040# a_151205_39260# 0.01257f
C357 a_161285_35122# a_154565_30440# 0.0534f
C358 a_164794_39200# a_162965_39260# 0.01256f
C359 a_156100_30440# a_151087_35509# 0.06801f
C360 a_121869_26660# VDD 5.599f
C361 VCTRL FS 0.08367f
C362 a_8825_43600# a_3667_44329# 0.04457f
C363 a_149525_26100# a_164645_30440# 0.03901f
C364 a_15545_21760# FB 0.08294f
C365 a_3785_30440# a_5347_39849# 0.04223f
C366 NB a_5347_22349# 0.74694f
C367 a_169567_35509# a_154447_35509# 0.16949f
C368 a_151060_30440# a_155984_43820# 0.05031f
C369 a_12627_2049# VDD 1.11895f
C370 a_12334_30380# a_3667_31029# 0.02243f
C371 a_157925_30440# a_162965_39260# 0.16502f
C372 a_121880_21939# a_121100_21999# 0.04699f
C373 a_3785_43600# a_6884_34720# 0.01092f
C374 a_173194_43820# VDD 0.60458f
C375 a_159605_30440# a_157780_39260# 0.0326f
C376 a_149407_26689# a_153034_26040# 0.01142f
C377 a_129500_21760# a_136932_26600# 0.01116f
C378 a_15545_21760# a_15400_26100# 0.07106f
C379 a_154565_30440# a_162965_39260# 0.1096f
C380 a_3785_43600# a_8564_34720# 0.01254f
C381 a_10360_43600# a_10654_43540# 0.01363f
C382 a_152885_39260# VCTRL 0.0303f
C383 a_161285_35122# a_156100_30440# 0.02568f
C384 a_13865_21760# FB 0.08194f
C385 a_152767_35509# a_162965_39260# 0.04032f
C386 a_161140_39260# a_154447_35509# 0.06255f
C387 a_153034_39200# a_152624_39200# 0.0129f
C388 a_166325_35122# a_151087_35509# 0.07249f
C389 a_3667_35369# a_22004_39060# 0.0103f
C390 a_15694_43540# a_13720_43600# 0.02878f
C391 a_3785_39120# a_18760_43600# 0.09068f
C392 a_152740_35122# a_154447_35509# 0.61532f
C393 a_157925_30440# a_166474_43820# 0.04336f
C394 a_156100_30440# a_162965_39260# 0.08063f
C395 a_159605_39260# a_151205_39260# 0.12991f
C396 a_149380_35122# a_164645_30440# 0.25518f
C397 FB a_149525_26100# 0.04359f
C398 a_15284_43540# a_15400_43600# 0.02865f
C399 a_10654_34720# VDD 0.34827f
C400 a_154447_35509# a_149407_31029# 0.07063f
C401 VDD a_3934_26040# 0.34678f
C402 a_149407_40129# VDD 4.81038f
C403 a_176144_26040# VDD 0.33901f
C404 a_171220_35122# a_164645_35122# 0.0645f
C405 a_151087_35509# a_151205_39260# 0.06687f
C406 a_151354_39200# VDD 0.59998f
C407 a_157780_39260# a_161140_39260# 0.04826f
C408 a_166325_35122# a_161285_35122# 0.09719f
C409 a_3785_43600# NB 0.02322f
C410 a_171220_35122# a_186224_26040# 0.02386f
C411 a_5347_44329# LO 0.14054f
C412 a_181594_39200# a_152885_21760# 0.04068f
C413 a_120920_26600# VDD 3.38049f
C414 a_152740_35122# a_157780_39260# 0.02901f
C415 a_34874_3780# VDD 0.35048f
C416 a_13865_30440# a_3667_44329# 0.04457f
C417 a_157780_39260# a_149407_31029# 0.0277f
C418 a_120984_21939# a_121100_21999# 0.04246f
C419 a_3785_43600# a_5614_34720# 0.01087f
C420 a_161285_35122# a_151205_39260# 0.06378f
C421 a_166325_35122# a_162965_39260# 0.76573f
C422 a_23684_34720# a_3785_30440# 0.02652f
C423 a_151060_30440# a_149525_26100# 6.02644f
C424 a_3667_26689# FB 0.44317f
C425 a_152767_35509# a_174874_43820# 0.05313f
C426 a_149407_26689# a_152624_26040# 0.02998f
C427 a_129500_21760# a_123480_21999# 0.0979f
C428 a_179504_43820# a_151087_35509# 0.02012f
C429 a_3785_43600# a_7294_34720# 0.0226f
C430 a_158074_39200# a_156245_39260# 0.01022f
C431 a_154447_40129# a_151087_22349# 0.03184f
C432 a_149407_26689# a_159605_39260# 0.03124f
C433 a_149380_35122# FB 0.04359f
C434 NB a_3667_31029# 0.69381f
C435 a_15400_26100# a_3667_26689# 0.0292f
C436 a_151205_39260# a_162965_39260# 0.35241f
C437 VDD a_14014_26040# 0.34827f
C438 a_19054_43540# a_18760_43600# 0.0133f
C439 a_149407_26689# a_151087_35509# 0.44551f
C440 a_3785_26100# a_3934_26040# 0.02481f
C441 a_16254_1742# a_15987_2189# 0.01727f
C442 a_171104_43820# a_164645_30440# 0.01044f
C443 a_15545_21760# a_15694_21700# 0.02481f
C444 a_3785_39120# a_3640_43600# 0.08755f
C445 a_152885_21760# a_154447_40129# 0.1474f
C446 a_151205_26100# a_151354_26040# 0.02332f
C447 a_12484_1400# VDD 0.36665f
C448 VDD a_164645_35122# 1.58969f
C449 a_150944_26040# a_149525_26100# 0.01254f
C450 a_157925_30440# a_154565_30440# 1.23401f
C451 a_186224_26040# VDD 0.33901f
C452 a_3785_43600# a_22120_39120# 0.08041f
C453 a_151205_39260# a_166064_39200# 0.01184f
C454 a_149407_26689# a_161285_35122# 0.03865f
C455 VCTRL a_149525_26100# 0.03341f
C456 a_24094_30380# a_3667_26689# 0.01991f
C457 a_151060_30440# a_149380_35122# 0.09244f
C458 a_157925_30440# a_152767_35509# 0.06728f
C459 a_151087_22349# a_151060_21760# 1.04996f
C460 a_149407_40129# a_154565_39260# 0.04153f
C461 a_181594_39200# a_181184_39200# 0.0129f
C462 a_126300_21700# VDD 1.21283f
C463 a_121493_21789# PB 0.50197f
C464 a_152767_35509# a_154565_30440# 0.06702f
C465 a_34464_3780# VDD 0.36295f
C466 a_156100_30440# a_157925_30440# 0.27154f
C467 a_149407_26689# a_162965_39260# 0.03865f
C468 a_152885_21760# a_151060_21760# 0.08021f
C469 a_159344_39200# VDD 0.63556f
C470 a_131280_26600# a_123480_21999# 0.01116f
C471 a_129500_21760# a_133241_26660# 0.77277f
C472 a_178234_43820# a_151087_35509# 0.04706f
C473 a_156100_30440# a_154565_30440# 0.34592f
C474 a_149407_40129# a_152885_39260# 0.09376f
C475 a_156100_30440# a_152767_35509# 0.07008f
C476 a_3667_26689# a_18760_43600# 0.25404f
C477 a_149380_35122# VCTRL 0.05826f
C478 a_154447_40129# a_156245_39260# 0.27868f
C479 a_166325_35122# a_157925_30440# 3.82954f
C480 a_151087_22349# a_154420_35122# 0.02581f
C481 VDD a_164384_39200# 0.63556f
C482 a_151205_26100# a_149525_26100# 0.3132f
C483 a_149674_26040# a_149525_26100# 0.02481f
C484 a_184954_26040# VDD 0.34678f
C485 a_166325_35122# a_154565_30440# 0.03789f
C486 a_3524_21700# VDD 0.36665f
C487 a_162704_30380# a_149380_35122# 0.01998f
C488 a_131180_21760# a_131474_21700# 0.01069f
C489 a_154565_39260# a_164645_35122# 0.09618f
C490 a_3667_35369# a_8825_43600# 0.60406f
C491 a_162704_43820# a_154565_30440# 0.01342f
C492 a_166325_35122# a_152767_35509# 0.07369f
C493 a_157925_30440# a_151205_39260# 1.44118f
C494 a_152885_21760# a_154420_35122# 0.06817f
C495 a_3524_34720# VDD 0.36665f
C496 a_169685_35122# a_151087_22349# 0.16672f
C497 a_17374_30380# a_13865_30440# 0.02254f
C498 a_154447_40129# a_149407_35509# 0.04598f
C499 a_151205_39260# a_154565_30440# 1.33165f
C500 a_156245_39260# a_151060_21760# 0.02501f
C501 a_169685_35122# a_186634_26040# 0.01988f
C502 a_166325_35122# a_156100_30440# 1.19008f
C503 a_8825_43600# a_5465_21760# 0.82698f
C504 a_158074_39200# VDD 0.5831f
C505 a_164384_43820# VDD 0.58276f
C506 a_178234_43820# a_177824_43820# 0.0129f
C507 a_5347_22349# a_24094_34720# 0.02871f
C508 a_151205_39260# a_152767_35509# 0.04328f
C509 a_159605_30440# a_151205_35122# 0.0303f
C510 a_169685_35122# a_152885_21760# 0.0418f
C511 a_151205_26100# a_149380_35122# 0.09411f
C512 a_154447_35509# a_154565_43880# 0.03983f
C513 a_154304_30380# a_149407_35509# 0.01396f
C514 a_3785_43600# a_10244_34720# 0.011f
C515 a_151087_35509# a_164645_30440# 0.04126f
C516 a_169567_35509# a_151205_35122# 0.78765f
C517 a_156100_30440# a_151205_39260# 0.06845f
C518 a_186634_30380# a_149407_40129# 0.02104f
C519 a_3785_39120# a_5320_43600# 0.076f
C520 a_154447_40129# a_171220_35122# 0.02657f
C521 a_8680_43600# a_8564_43540# 0.02888f
C522 a_149380_35122# a_166325_39260# 0.10929f
C523 a_138624_26600# VDD 0.82855f
C524 a_149407_26689# a_157925_30440# 0.05657f
C525 a_149407_35509# a_151060_21760# 0.05958f
C526 a_184544_26040# VDD 0.36495f
C527 a_181594_39200# VDD 0.60254f
C528 a_164384_43820# a_164794_43820# 0.0129f
C529 a_149407_26689# a_154565_30440# 1.12044f
C530 a_161285_35122# a_164645_30440# 0.03865f
C531 NB a_123480_21999# 0.61925f
C532 a_163114_35062# a_161285_35122# 0.01401f
C533 a_151205_35122# a_161140_39260# 0.02996f
C534 a_156245_39260# a_154420_35122# 0.02778f
C535 a_149407_26689# a_152767_35509# 0.54258f
C536 a_149407_40129# a_149525_26100# 0.27714f
C537 a_8825_43600# a_12185_21760# 0.03124f
C538 a_17080_34780# a_8825_43600# 0.04869f
C539 a_3667_35369# a_13865_30440# 0.0361f
C540 VDD a_5614_26040# 0.34827f
C541 a_159605_39260# FB 0.04359f
C542 a_152740_35122# a_151205_35122# 0.70341f
C543 a_166325_35122# a_151205_39260# 0.02487f
C544 a_179504_39200# a_179914_39200# 0.0129f
C545 VDD a_176554_39200# 0.58394f
C546 a_171220_35122# a_151060_21760# 0.05716f
C547 a_151205_35122# a_149407_31029# 0.03167f
C548 a_164645_30440# a_162965_39260# 0.03865f
C549 a_151087_35509# FB 0.15633f
C550 a_149407_26689# a_156100_30440# 1.66469f
C551 a_163114_43820# VDD 0.60275f
C552 VDD a_151354_43820# 0.59998f
C553 a_3785_3840# a_3667_5549# 1.23237f
C554 a_169685_35122# a_156245_39260# 0.25939f
C555 a_8825_43600# a_5347_22349# 0.11155f
C556 a_13604_21700# VDD 0.36495f
C557 a_154447_40129# VDD 6.47626f
C558 a_149407_35509# a_154420_35122# 0.03341f
C559 a_3785_43600# a_8974_34720# 0.02469f
C560 a_186224_30380# a_149407_40129# 0.01169f
C561 a_8680_26100# a_5347_39849# 0.27173f
C562 a_131180_21760# a_134424_21700# 0.01324f
C563 a_149407_40129# a_149380_35122# 0.06654f
C564 a_151060_30440# a_151087_35509# 0.08013f
C565 a_159605_30440# a_169685_39260# 0.04525f
C566 a_149407_26689# a_166325_35122# 0.46681f
C567 a_27034_3780# a_25205_4182# 0.0245f
C568 a_5347_44329# a_8680_39120# 0.08298f
C569 VDD a_179914_43820# 0.58512f
C570 a_3785_26100# a_5614_26040# 0.02312f
C571 FB a_162965_39260# 0.0412f
C572 NB a_133241_26660# 1.32642f
C573 a_171220_35122# a_154420_35122# 0.04143f
C574 a_169567_35509# a_169685_39260# 0.41442f
C575 a_151205_26100# a_153034_26040# 0.02148f
C576 a_14307_2049# VDD 0.17932f
C577 NB a_5347_39849# 0.15864f
C578 a_138894_34922# ICP2 0.01179f
C579 VDD a_5204_26040# 0.36281f
C580 a_156100_30440# a_155984_30380# 0.01998f
C581 a_149407_26689# a_151205_39260# 0.31178f
C582 VDD a_151060_21760# 3.65263f
C583 a_8825_43600# a_13720_43600# 0.15961f
C584 a_17080_34780# a_13865_30440# 0.07788f
C585 NB a_3785_30440# 0.23962f
C586 a_3785_43600# a_8825_43600# 1.69412f
C587 VCTRL a_159605_39260# 0.03488f
C588 a_15987_2189# VDD 0.57807f
C589 a_171514_26040# a_161140_39260# 0.01069f
C590 a_169685_35122# a_171220_35122# 1.97256f
C591 a_151087_35509# VCTRL 0.03688f
C592 a_8564_21700# VDD 0.36293f
C593 a_121493_21789# VCTRL 0.04359f
C594 a_5347_39849# a_7294_39060# 0.01066f
C595 a_152740_35122# a_169685_39260# 0.11425f
C596 a_13865_30440# a_5347_22349# 0.17122f
C597 a_181184_43820# VDD 0.63535f
C598 a_186224_39542# a_151060_30440# 0.01402f
C599 a_151060_30440# a_188604_34720# 0.02212f
C600 a_169685_39260# a_149407_31029# 0.03012f
C601 a_149380_35122# a_164645_35122# 0.02359f
C602 a_157925_30440# a_164645_30440# 0.09791f
C603 a_154447_40129# a_154565_39260# 0.43995f
C604 a_161285_35122# VCTRL 0.03167f
C605 a_152740_35122# a_176554_43820# 0.01005f
C606 a_8825_43600# a_3667_31029# 0.14926f
C607 a_121493_21789# a_122881_26660# 0.27097f
C608 a_154447_40129# FS 0.03076f
C609 a_154565_30440# a_164645_30440# 0.45789f
C610 VDD a_154420_35122# 2.4726f
C611 a_131280_26600# a_129500_21760# 0.01414f
C612 a_185654_34720# a_183125_39602# 0.02458f
C613 a_149264_43820# a_149674_43820# 0.0129f
C614 PB a_34200_21944# 9.52928f
C615 a_12894_1400# VDD 0.34678f
C616 a_152767_35509# a_164645_30440# 0.04007f
C617 VCTRL a_162965_39260# 0.02805f
C618 a_187334_34720# a_183125_39602# 0.01988f
C619 a_152740_35122# a_149380_39260# 0.03425f
C620 VDD a_3667_44329# 2.23989f
C621 a_3785_43600# a_8680_43600# 0.09258f
C622 a_156100_30440# a_164645_30440# 0.04188f
C623 a_169685_35122# VDD 1.46582f
C624 a_140574_34580# a_138745_34982# 0.02929f
C625 a_149407_31029# a_149380_39260# 0.0727f
C626 a_154565_39260# a_151060_21760# 0.02971f
C627 a_3785_43600# a_13865_30440# 0.03601f
C628 a_127916_21700# VDD 1.21522f
C629 a_187904_26040# a_151060_21760# 0.02671f
C630 a_157925_30440# FB 1.95623f
C631 a_5347_44329# a_10360_43600# 0.04198f
C632 FS a_151060_21760# 0.22848f
C633 a_166064_39200# a_166474_39200# 0.0129f
C634 a_5204_3780# a_3667_5549# 0.01207f
C635 FB a_154565_30440# 2.26754f
C636 a_154565_39260# a_161434_26040# 0.02481f
C637 a_157780_39260# a_154447_35509# 0.02789f
C638 FB a_152767_35509# 0.04359f
C639 a_176144_43820# a_176554_43820# 0.0129f
C640 a_158074_30380# a_157925_30440# 0.02481f
C641 a_166325_35122# a_164645_30440# 0.0356f
C642 a_121493_21789# a_121869_26660# 0.46866f
C643 a_152885_39260# a_151060_21760# 0.03918f
C644 a_156245_39260# a_163114_26040# 0.02648f
C645 a_151060_30440# a_157925_30440# 0.07034f
C646 a_163114_30380# a_157925_30440# 0.02019f
C647 a_156100_30440# a_183125_39602# 0.47941f
C648 a_156100_30440# FB 0.04074f
C649 a_3785_26100# a_3667_44329# 0.04345f
C650 a_13720_30440# a_5347_39849# 0.07309f
C651 a_139520_26600# VDD 0.82855f
C652 a_151060_30440# a_154565_30440# 0.07147f
C653 a_151205_39260# a_164645_30440# 0.0842f
C654 a_154565_39260# a_154420_35122# 0.02581f
C655 VDD ICP2 2.58008f
C656 a_166325_39260# a_162965_39260# 0.20971f
C657 a_151060_30440# a_152767_35509# 0.03383f
C658 a_131180_21760# a_132744_21700# 0.02406f
C659 FS a_154420_35122# 0.03364f
C660 a_172784_43820# a_154447_35509# 0.01259f
C661 a_152740_35122# a_172784_30380# 0.01998f
C662 a_25205_4182# a_26624_3780# 0.01045f
C663 a_149407_40129# a_159605_39260# 0.06217f
C664 a_174464_43820# a_174874_43820# 0.0129f
C665 a_156100_30440# a_151060_30440# 0.62303f
C666 a_12334_21700# VDD 0.34678f
C667 a_166325_35122# FB 0.53384f
C668 a_149407_40129# a_151087_35509# 0.14351f
C669 a_177824_39200# a_178234_39200# 0.0129f
C670 a_129500_21760# NB 1.55008f
C671 a_152885_39260# a_154420_35122# 0.02581f
C672 a_157925_30440# VCTRL 0.02659f
C673 VCTRL a_154565_30440# 0.0303f
C674 a_154447_40129# a_149525_26100# 0.0899f
C675 a_15284_21700# VDD 0.36495f
C676 a_171104_26040# a_161140_39260# 0.01998f
C677 a_151205_39260# FB 0.0412f
C678 a_171104_35062# a_171220_35122# 0.01149f
C679 a_149407_26689# a_164645_30440# 0.17264f
C680 a_3667_44329# a_3785_21760# 0.11043f
C681 a_159344_39200# a_159754_39200# 0.0129f
C682 VCTRL a_152767_35509# 0.03394f
C683 a_3785_39120# a_3667_44329# 0.53931f
C684 a_166325_35122# a_151060_30440# 0.98302f
C685 a_176554_30380# VDD 0.34666f
C686 a_121100_21999# VDD 2.36202f
C687 a_157664_39200# a_157780_39260# 0.0425f
C688 a_8564_26040# a_8680_26100# 0.01998f
C689 a_156100_30440# VCTRL 0.02659f
C690 a_33194_4122# a_25205_4182# 0.01179f
C691 a_34200_21944# FB 9.52928f
C692 a_17374_30380# VDD 0.34827f
C693 a_149407_40129# a_162965_39260# 0.0606f
C694 a_151060_30440# a_151205_39260# 0.04391f
C695 a_159605_39260# a_164645_35122# 0.09064f
C696 a_151060_21760# a_149525_26100# 0.0624f
C697 a_25205_4182# a_25354_4122# 0.01511f
C698 a_174464_43820# a_152767_35509# 0.01342f
C699 a_5614_21700# a_5465_21760# 0.02496f
C700 a_154447_40129# a_149380_35122# 0.23489f
C701 a_11924_21700# VDD 0.36569f
C702 a_159605_30440# a_159754_30380# 0.02481f
C703 a_149407_26689# a_183125_39602# 0.04092f
C704 a_149407_26689# FB 0.13141f
C705 a_151087_35509# a_164645_35122# 0.03444f
C706 a_166325_35122# VCTRL 0.0354f
C707 a_17934_1742# VDD 0.21432f
C708 a_157925_30440# a_166325_39260# 0.02599f
C709 a_15545_21760# a_3667_44329# 0.08267f
C710 a_10244_21700# VDD 0.36279f
C711 a_14014_21700# VDD 0.34678f
C712 a_164645_30440# a_169834_43820# 0.04741f
C713 a_3667_44329# a_7000_39120# 0.08816f
C714 a_161285_35122# a_164645_35122# 0.10745f
C715 VCTRL a_151205_39260# 0.03167f
C716 a_8974_26040# a_5347_39849# 0.02322f
C717 a_149407_26689# a_151060_30440# 0.03094f
C718 PB FB 0.07666f
C719 a_176144_30380# VDD 0.36391f
C720 a_149380_35122# a_151060_21760# 2.30323f
C721 REFCK VDD 0.6143f
C722 a_13865_21760# a_3667_44329# 0.07218f
C723 a_3667_35369# VDD 4.89471f
C724 a_159605_30440# a_151087_22349# 0.04383f
C725 a_154420_35122# a_149525_26100# 0.07079f
C726 a_16964_30380# VDD 0.3627f
C727 a_164645_35122# a_162965_39260# 1.07085f
C728 a_5347_44329# PB 0.03851f
C729 a_156100_30440# a_166325_39260# 0.07508f
C730 a_166325_35122# a_168154_35062# 0.01805f
C731 a_156100_30440# a_189584_39542# 0.01165f
C732 VCTRL a_34200_21944# 0.27268f
C733 a_149407_35509# a_152740_43880# 0.03646f
C734 a_169567_35509# a_151087_22349# 0.29631f
C735 VDD a_5465_21760# 3.16403f
C736 a_159605_30440# a_152885_21760# 0.95095f
C737 a_5347_44329# a_25354_4122# 0.01179f
C738 a_10654_21700# VDD 0.34967f
C739 a_8825_43600# a_3785_30440# 1.09396f
C740 a_149407_26689# VCTRL 0.06981f
C741 a_169567_35509# a_152885_21760# 0.43888f
C742 a_149407_40129# a_157925_30440# 0.06263f
C743 a_151087_22349# a_161140_39260# 0.09253f
C744 a_8974_21700# VDD 0.34967f
C745 a_151205_35122# a_154447_35509# 0.09162f
C746 a_166325_35122# a_166325_39260# 0.21483f
C747 a_149380_35122# a_154420_35122# 0.11728f
C748 a_13720_30440# a_13604_30380# 0.01998f
C749 a_159344_43820# VDD 0.63244f
C750 a_149407_40129# a_154565_30440# 0.06764f
C751 a_152740_35122# a_151087_22349# 0.03057f
C752 a_3667_35369# a_3785_26100# 0.04359f
C753 a_3667_26689# a_3667_44329# 0.04457f
C754 a_3785_3840# a_3524_3780# 0.01867f
C755 a_151087_22349# a_149407_31029# 0.03208f
C756 a_126300_21700# a_123769_21999# 0.05081f
C757 a_149407_40129# a_152767_35509# 1.998f
C758 a_152885_21760# a_161140_39260# 0.03557f
C759 a_151205_39260# a_166325_39260# 0.0634f
C760 a_3785_39120# a_3640_39120# 0.36358f
C761 a_151205_35122# a_157780_39260# 0.02484f
C762 a_183125_39602# a_183274_39542# 0.01511f
C763 VDD a_12185_21760# 2.99219f
C764 a_152740_35122# a_152885_21760# 0.15286f
C765 a_164384_39200# a_162965_39260# 0.01281f
C766 PB VCTRL 0.04457f
C767 a_3785_26100# a_5465_21760# 0.04402f
C768 a_174464_26040# a_162965_39260# 0.01071f
C769 a_156100_30440# a_149407_40129# 0.06755f
C770 a_184954_43820# a_184544_43820# 0.0129f
C771 a_152885_21760# a_149407_31029# 0.04025f
C772 a_159605_30440# a_156245_39260# 0.48929f
C773 a_138745_34982# a_140164_34580# 0.01318f
C774 a_151354_30380# a_151060_30440# 0.01069f
C775 a_5347_44329# a_25205_4182# 0.12775f
C776 a_13865_30440# a_5347_39849# 0.35695f
C777 FB a_164645_30440# 0.04359f
C778 a_149407_26689# a_151205_26100# 0.7955f
C779 a_164645_35122# a_164794_39200# 0.04787f
C780 VDD a_5347_22349# 5.83351f
C781 PB a_122881_26660# 2.78064f
C782 a_5614_39060# a_3640_39120# 0.02878f
C783 a_13865_30440# a_3785_30440# 0.04223f
C784 a_157925_30440# a_164645_35122# 0.83612f
C785 a_13865_21760# a_15284_21700# 0.01304f
C786 a_5320_21760# a_5465_21760# 0.39434f
C787 a_152740_43880# VDD 2.57405f
C788 a_3667_35369# a_3785_21760# 0.04359f
C789 a_169567_35509# a_183274_26040# 0.02665f
C790 a_166325_35122# a_149407_40129# 0.17704f
C791 a_158074_43820# VDD 0.60458f
C792 a_164645_35122# a_154565_30440# 0.02679f
C793 a_159605_30440# a_149407_35509# 0.07232f
C794 a_3667_35369# a_3785_39120# 0.03841f
C795 a_3785_26100# a_12185_21760# 0.03791f
C796 a_164645_35122# a_152767_35509# 0.03451f
C797 a_151060_30440# a_164645_30440# 0.0324f
C798 a_156245_39260# a_161140_39260# 0.53224f
C799 a_154565_39260# a_162704_26040# 0.01384f
C800 a_5465_21760# a_3785_21760# 0.06222f
C801 a_149407_40129# a_151205_39260# 0.08899f
C802 a_154447_40129# a_159605_39260# 0.14834f
C803 a_152740_35122# a_156245_39260# 0.02873f
C804 a_151354_39200# a_151205_39260# 0.04971f
C805 a_169685_39260# a_154447_35509# 0.10572f
C806 a_183125_39602# FB 0.1718f
C807 a_156100_30440# a_164645_35122# 0.04203f
C808 a_156245_39260# a_149407_31029# 0.06675f
C809 a_19054_34720# a_17080_34780# 0.01988f
C810 a_154447_40129# a_151087_35509# 0.62179f
C811 a_149407_40129# a_184544_43820# 0.01259f
C812 a_3785_43600# VDD 5.12974f
C813 a_159605_30440# a_171220_35122# 0.05371f
C814 a_5347_44329# FB 0.12165f
C815 a_3785_26100# a_5347_22349# 0.15506f
C816 a_138745_34982# a_138894_34922# 0.01629f
C817 a_3667_35369# a_16964_34720# 0.01025f
C818 a_150944_30380# a_151060_30440# 0.01998f
C819 a_3667_35369# a_20734_34720# 0.02091f
C820 a_164384_39200# a_164794_39200# 0.0129f
C821 a_181884_34720# a_152740_43880# 0.01998f
C822 PB a_121869_26660# 2.85381f
C823 a_169567_35509# a_171220_35122# 0.7028f
C824 a_5204_39060# a_3640_39120# 0.01037f
C825 a_161285_35122# a_154447_40129# 0.03167f
C826 a_186634_43820# a_186224_43820# 0.0129f
C827 a_151087_35509# a_179914_43820# 0.04074f
C828 VCTRL a_164645_30440# 0.0303f
C829 a_152740_35122# a_149407_35509# 0.03311f
C830 a_3667_35369# a_15545_21760# 0.07693f
C831 a_151060_30440# FB 0.10763f
C832 a_13865_21760# a_14014_21700# 0.02648f
C833 a_152624_43820# VDD 0.58373f
C834 a_159605_39260# a_151060_21760# 0.03132f
C835 a_149407_35509# a_149407_31029# 0.32422f
C836 a_149407_26689# a_149407_40129# 0.23118f
C837 a_12185_21760# a_3785_21760# 0.03849f
C838 a_154447_35509# a_149380_39260# 0.04018f
C839 a_5320_21760# a_5347_22349# 0.05272f
C840 a_151087_35509# a_151060_21760# 0.1413f
C841 VDD a_3667_31029# 3.26546f
C842 a_154447_40129# a_162965_39260# 0.03167f
C843 VDD a_162704_39200# 0.63738f
C844 a_171220_35122# a_161140_39260# 0.06222f
C845 a_13865_21760# a_3667_35369# 0.03849f
C846 a_151205_39260# a_164645_35122# 1.30541f
C847 a_152740_35122# a_171220_35122# 0.03019f
C848 a_13720_30440# NB 0.18966f
C849 a_151354_39200# a_150944_39200# 0.0129f
C850 a_3785_43600# a_3785_26100# 0.32897f
C851 a_151205_35122# a_151354_35062# 0.01386f
C852 a_5347_22349# a_3785_21760# 0.0919f
C853 a_157780_39260# a_149380_39260# 0.25427f
C854 a_161285_35122# a_151060_21760# 1.43255f
C855 a_171220_35122# a_149407_31029# 0.0331f
C856 a_159605_30440# VDD 2.25882f
C857 REFCK LO 0.03034f
C858 VCTRL FB 0.66137f
C859 a_164384_43820# a_154565_30440# 0.01202f
C860 a_3785_39120# a_5347_22349# 0.06894f
C861 a_168154_39200# VDD 0.5834f
C862 a_17080_34780# a_16964_34720# 0.01998f
C863 FB a_18760_43600# 0.13141f
C864 a_159605_39260# a_154420_35122# 0.03488f
C865 a_169567_35509# VDD 3.23816f
C866 a_151060_21760# a_162965_39260# 0.02568f
C867 a_174464_39200# a_171220_35122# 0.01279f
C868 a_151087_35509# a_154420_35122# 0.515f
C869 a_3785_26100# a_3667_31029# 0.13675f
C870 a_5204_43540# a_3640_43600# 0.01745f
C871 a_156100_30440# a_164384_43820# 0.05499f
C872 a_149407_26689# a_164645_35122# 0.03234f
C873 VDD a_186224_43820# 0.63502f
C874 a_169567_35509# a_188314_26040# 0.01993f
C875 a_3667_35369# a_3667_26689# 0.03072f
C876 a_151060_30440# VCTRL 0.0313f
C877 a_161140_39260# VDD 1.85979f
C878 VDD a_161434_39200# 0.58311f
C879 a_3785_43600# a_3785_21760# 0.04972f
C880 a_161285_35122# a_154420_35122# 0.03167f
C881 a_154714_30380# a_154565_30440# 0.02481f
C882 a_152740_35122# VDD 2.43363f
C883 a_141760_26839# a_121869_26660# 0.04246f
C884 a_3785_3840# a_7294_3780# 0.04947f
C885 a_3785_39120# a_13720_43600# 0.08579f
C886 a_13865_21760# a_12185_21760# 0.05764f
C887 a_22004_39060# a_22120_39120# 0.01998f
C888 a_15545_21760# a_5347_22349# 0.08039f
C889 a_3667_26689# a_5465_21760# 0.03557f
C890 VDD a_149407_31029# 3.24398f
C891 a_3785_43600# a_3785_39120# 0.86964f
C892 a_3524_3780# a_3934_3780# 0.02581f
C893 a_161434_30380# VDD 0.34107f
C894 a_19054_43540# a_5347_22349# 0.01066f
C895 a_8680_39120# a_3667_44329# 0.07981f
C896 a_154420_35122# a_162965_39260# 0.02805f
C897 a_163114_43820# a_154565_30440# 0.05313f
C898 a_184954_39542# a_183125_39602# 0.01519f
C899 a_167744_39200# VDD 0.58329f
C900 a_13865_21760# a_5347_22349# 0.10709f
C901 a_154447_40129# a_157925_30440# 0.21478f
C902 a_159605_30440# a_154565_39260# 0.03949f
C903 a_12334_26040# a_5347_39849# 0.02246f
C904 a_138745_34982# VDD 2.82519f
C905 a_174464_39200# VDD 0.63502f
C906 a_3667_31029# a_3785_21760# 0.04575f
C907 a_158074_39200# a_151205_39260# 0.05059f
C908 a_154447_40129# a_154565_30440# 0.11241f
C909 a_169685_35122# a_162965_39260# 0.32341f
C910 a_3785_39120# a_3667_31029# 0.04499f
C911 a_5347_44329# a_3640_43600# 0.05656f
C912 a_154447_40129# a_152767_35509# 0.60187f
C913 a_149407_40129# a_164645_30440# 0.03348f
C914 a_152740_43880# a_154714_43820# 0.01434f
C915 a_171514_30380# a_152767_35509# 0.02332f
C916 a_169567_35509# FS 0.07311f
C917 a_161024_39200# VDD 0.58576f
C918 a_3785_43600# a_15545_21760# 0.03582f
C919 a_121493_21789# ICP2 0.03551f
C920 a_3667_26689# a_12185_21760# 0.03557f
C921 a_17080_34780# a_3667_26689# 0.03412f
C922 a_152740_43880# a_149525_26100# 0.03261f
C923 a_159605_30440# a_152885_39260# 0.03526f
C924 a_3785_43600# a_7000_39120# 0.0685f
C925 a_156100_30440# a_154447_40129# 0.13417f
C926 a_12627_2049# a_5347_44329# 0.42945f
C927 a_176144_43820# VDD 0.58276f
C928 a_3785_3840# a_6884_3780# 0.01144f
C929 a_157925_30440# a_151060_21760# 0.14563f
C930 a_154565_39260# a_161140_39260# 1.88712f
C931 VDD a_157664_43820# 0.63246f
C932 a_154565_39260# a_161434_39200# 0.01169f
C933 a_151060_21760# a_154565_30440# 0.04463f
C934 a_164794_30380# a_164645_30440# 0.02332f
C935 a_152740_35122# a_154565_39260# 0.0349f
C936 a_13865_21760# a_3785_43600# 0.03791f
C937 a_161024_30380# VDD 0.33892f
C938 a_3667_26689# a_5347_22349# 0.20176f
C939 a_3785_3840# a_3934_3780# 0.09039f
C940 a_3667_5549# VDD 1.22314f
C941 a_152767_35509# a_151060_21760# 0.0399f
C942 a_154565_39260# a_149407_31029# 0.06178f
C943 a_123480_21999# VDD 1.03799f
C944 a_163114_43820# a_162704_43820# 0.0129f
C945 a_152740_35122# FS 0.0633f
C946 a_151205_26100# VCTRL 0.0303f
C947 a_149407_40129# a_183125_39602# 0.26188f
C948 a_149407_40129# FB 0.15995f
C949 a_15400_26100# a_15284_26040# 0.01998f
C950 FS a_149407_31029# 0.01239f
C951 a_166325_35122# a_154447_40129# 0.03755f
C952 a_8825_43600# NB 0.11816f
C953 a_149407_35509# a_154565_43880# 0.03993f
C954 a_156100_30440# a_151060_21760# 0.08077f
C955 a_5204_43540# a_5320_43600# 0.02865f
C956 a_151205_35122# a_169685_39260# 0.06415f
C957 a_149380_35122# a_152740_43880# 0.04076f
C958 a_150944_43820# a_151354_43820# 0.0129f
C959 a_129608_26600# VDD 3.35828f
C960 a_152740_35122# a_152885_39260# 0.03066f
C961 a_166325_39260# a_166474_39200# 0.04654f
C962 a_3667_35369# a_22414_34720# 0.01988f
C963 a_164645_35122# a_164645_30440# 0.0615f
C964 a_187904_43820# a_188314_43820# 0.0129f
C965 a_3785_39120# a_20440_43600# 0.09113f
C966 a_183564_34720# a_152740_43880# 0.01256f
C967 a_18644_43540# a_18760_43600# 0.02888f
C968 a_121493_21789# a_121100_21999# 0.23365f
C969 a_154447_40129# a_151205_39260# 0.2801f
C970 a_157925_30440# a_154420_35122# 0.05783f
C971 a_152885_39260# a_149407_31029# 0.07501f
C972 a_6884_30380# VDD 0.36272f
C973 a_149407_40129# a_151060_30440# 0.08467f
C974 a_154420_35122# a_154565_30440# 0.06286f
C975 a_3785_43600# a_3667_26689# 0.04188f
C976 a_166325_35122# a_151060_21760# 0.06475f
C977 a_152767_35509# a_154420_35122# 0.14559f
C978 a_22120_39120# a_24094_39060# 0.01988f
C979 a_121869_26660# a_122881_26660# 3.85276f
C980 a_151205_35122# a_149380_39260# 0.03341f
C981 a_156100_30440# a_154420_35122# 0.06414f
C982 a_133241_26660# VDD 0.33039f
C983 a_179914_26040# a_151087_22349# 0.0209f
C984 a_151205_39260# a_151060_21760# 0.01981f
C985 FB a_164645_35122# 0.03676f
C986 VDD a_5347_39849# 4.0754f
C987 a_169685_35122# a_152767_35509# 0.02927f
C988 a_149407_26689# a_154447_40129# 0.24384f
C989 a_151087_22349# a_154447_35509# 0.2619f
C990 a_5347_44329# a_5320_43600# 0.15898f
C991 a_13865_30440# NB 0.57881f
C992 VDD a_3785_30440# 0.84266f
C993 a_179504_43820# a_179914_43820# 0.0129f
C994 a_149407_40129# VCTRL 0.08031f
C995 a_176144_30380# a_151087_35509# 0.01082f
C996 a_182294_34720# a_152740_43880# 0.01069f
C997 a_149264_39200# a_149674_39200# 0.0129f
C998 a_152885_21760# a_154447_35509# 0.03582f
C999 a_189584_43820# VDD 0.63244f
C1000 a_166325_35122# a_154420_35122# 0.03755f
C1001 VDD a_154565_43880# 3.2807f
C1002 a_151087_22349# a_157780_39260# 0.0256f
C1003 a_169424_26040# a_157780_39260# 0.0242f
C1004 a_5614_30380# VDD 0.34727f
C1005 a_6884_3780# a_7294_3780# 0.0129f
C1006 a_149407_26689# a_151060_21760# 0.57497f
C1007 a_159605_30440# a_149380_35122# 0.07348f
C1008 a_151205_39260# a_154420_35122# 0.03167f
C1009 a_152740_35122# a_149525_26100# 0.14549f
C1010 a_3785_26100# a_5347_39849# 0.31501f
C1011 a_149380_39260# a_149674_39200# 0.01575f
C1012 a_149407_31029# a_149525_26100# 0.07912f
C1013 a_179504_26040# a_151087_22349# 0.01119f
C1014 a_3785_26100# a_3785_30440# 0.11731f
C1015 a_151205_26100# a_149407_40129# 0.10222f
C1016 a_14014_30380# a_13865_30440# 0.02347f
C1017 a_169685_35122# a_151205_39260# 0.17782f
C1018 VCTRL a_164645_35122# 0.02484f
C1019 a_181184_26040# a_171220_35122# 0.02216f
C1020 a_179504_43820# a_154420_35122# 0.04076f
C1021 a_5204_34720# VDD 0.36281f
C1022 a_19054_30380# a_13865_30440# 0.02254f
C1023 a_20440_43600# a_3667_26689# 0.02451f
C1024 a_149407_40129# a_184954_43820# 0.04757f
C1025 a_156245_39260# a_154447_35509# 0.17259f
C1026 a_5614_43540# a_3640_43600# 0.02882f
C1027 a_149380_35122# a_161140_39260# 0.03124f
C1028 a_149264_39200# a_149380_39260# 0.0411f
C1029 a_11924_43540# a_10360_43600# 0.01133f
C1030 a_188314_43820# VDD 0.58576f
C1031 a_149407_26689# a_154420_35122# 0.86186f
C1032 a_3524_43540# a_3640_43600# 0.02888f
C1033 VDD a_154304_43820# 0.63738f
C1034 a_152740_35122# a_149380_35122# 2.11243f
C1035 a_6884_39060# a_3785_21760# 0.01608f
C1036 a_149380_35122# a_149407_31029# 0.05692f
C1037 a_3785_21760# a_5347_39849# 0.60246f
C1038 a_22414_26040# VDD 0.34888f
C1039 a_155984_39200# a_156394_39200# 0.0129f
C1040 a_156245_39260# a_157780_39260# 2.76922f
C1041 a_176144_39200# a_176554_39200# 0.0129f
C1042 a_5614_3780# a_5204_3780# 0.02581f
C1043 a_169685_35122# a_149407_26689# 0.03706f
C1044 a_3785_30440# a_3785_21760# 0.04223f
C1045 a_149407_35509# a_154447_35509# 0.03849f
C1046 a_151087_35509# a_152740_43880# 0.03836f
C1047 a_157664_35062# a_149407_26689# 0.01165f
C1048 a_154447_40129# a_164645_30440# 0.32706f
C1049 a_13720_30440# a_13865_30440# 0.39305f
C1050 a_189994_26040# FB 0.01988f
C1051 LO a_3667_5549# 2.54798f
C1052 a_12334_34720# a_8825_43600# 0.02074f
C1053 a_184954_30380# VDD 0.34107f
C1054 a_22414_39060# a_3667_44329# 0.01993f
C1055 PB a_3667_44329# 0.03998f
C1056 a_18644_30380# a_13865_30440# 0.0103f
C1057 a_3934_34720# VDD 0.34678f
C1058 a_149407_35509# a_157780_39260# 0.03557f
C1059 a_171220_35122# a_154447_35509# 0.26288f
C1060 a_5320_43600# a_3640_43600# 0.26266f
C1061 a_34200_21944# ICP2 9.52928f
C1062 a_131064_21700# a_131180_21760# 0.01998f
C1063 a_3667_35369# a_10360_43600# 0.09694f
C1064 a_129500_21760# VDD 0.31269f
C1065 a_6884_39060# a_7000_39120# 0.02888f
C1066 a_15545_21760# a_5347_39849# 0.05687f
C1067 a_151060_21760# a_164645_30440# 0.03557f
C1068 a_7000_39120# a_5347_39849# 0.08135f
C1069 a_189584_43820# a_189994_43820# 0.0129f
C1070 a_186924_34720# a_152740_43880# 0.02459f
C1071 a_8564_30380# VDD 0.36272f
C1072 a_15545_21760# a_3785_30440# 0.03791f
C1073 a_154447_40129# FB 0.16947f
C1074 a_176144_39200# a_151060_21760# 0.06237f
C1075 a_3785_39120# a_3934_39060# 0.03448f
C1076 a_163114_39200# a_162704_39200# 0.0129f
C1077 a_13865_21760# a_5347_39849# 0.04223f
C1078 a_3785_43600# a_8680_39120# 0.04619f
C1079 a_15400_43600# a_5347_22349# 0.13667f
C1080 a_13865_21760# a_3785_30440# 0.03791f
C1081 a_132734_34580# VDD 0.35048f
C1082 a_189584_26040# FB 0.01162f
C1083 a_184544_30380# VDD 0.33892f
C1084 a_5320_43600# a_5614_43540# 0.01363f
C1085 VDD a_154447_35509# 4.10023f
C1086 a_154447_40129# a_151060_30440# 0.03267f
C1087 a_133241_26660# a_134996_21700# 0.02301f
C1088 a_8974_30380# a_3667_31029# 0.02243f
C1089 a_149407_40129# a_164645_35122# 0.03005f
C1090 a_22414_26040# a_3785_21760# 0.0264f
C1091 a_178234_39200# VDD 0.60202f
C1092 FB a_151060_21760# 0.2524f
C1093 a_183125_39602# a_151060_21760# 0.04474f
C1094 a_159605_30440# a_159605_39260# 0.07748f
C1095 a_5347_44329# a_14307_2049# 0.1184f
C1096 a_154420_35122# a_164645_30440# 0.02581f
C1097 a_138624_26600# a_122881_26660# 0.06285f
C1098 a_151205_35122# a_151087_22349# 0.0303f
C1099 a_159605_30440# a_151087_35509# 0.07917f
C1100 a_152885_39260# a_158074_26040# 0.02481f
C1101 a_154714_43820# a_154565_43880# 0.04906f
C1102 a_157780_39260# VDD 2.03893f
C1103 a_189584_43820# a_149525_26100# 0.01749f
C1104 a_151354_21700# a_151060_21760# 0.01069f
C1105 a_5347_44329# a_15987_2189# 0.05702f
C1106 a_154565_43880# a_149525_26100# 0.07572f
C1107 a_7294_30380# VDD 0.34827f
C1108 a_15400_43600# a_13720_43600# 0.2601f
C1109 a_169567_35509# a_151087_35509# 0.11324f
C1110 a_3667_26689# a_5347_39849# 0.86092f
C1111 a_169685_35122# a_164645_30440# 0.04139f
C1112 a_152885_21760# a_151205_35122# 0.03621f
C1113 a_161140_39260# a_163114_39200# 0.0111f
C1114 a_151060_30440# a_151060_21760# 0.87365f
C1115 a_12334_30380# VDD 0.34888f
C1116 a_159605_30440# a_161285_35122# 0.04139f
C1117 a_154447_40129# VCTRL 0.07686f
C1118 a_154304_26040# a_149380_39260# 0.01998f
C1119 a_3667_26689# a_3785_30440# 0.04223f
C1120 a_159605_39260# a_161140_39260# 0.5726f
C1121 a_159605_39260# a_161434_39200# 0.05346f
C1122 PB a_121100_21999# 0.14018f
C1123 a_132324_34580# VDD 0.36295f
C1124 FB a_154420_35122# 0.08095f
C1125 a_157925_30440# a_152740_43880# 0.06824f
C1126 a_152740_35122# a_159605_39260# 0.0343f
C1127 a_151087_35509# a_161140_39260# 0.02761f
C1128 VDD a_172784_43820# 0.63502f
C1129 a_159605_30440# a_162965_39260# 0.04289f
C1130 a_133241_26660# a_134424_21700# 0.02265f
C1131 a_159605_39260# a_149407_31029# 0.03208f
C1132 a_174874_26040# a_164645_35122# 0.02665f
C1133 a_152740_35122# a_151087_35509# 0.24429f
C1134 a_152740_43880# a_154565_30440# 0.0725f
C1135 a_177824_39200# VDD 0.63502f
C1136 a_168154_39200# a_162965_39260# 0.01378f
C1137 FB a_3667_44329# 0.26634f
C1138 a_149380_35122# a_154565_43880# 0.04261f
C1139 a_8680_43600# a_8825_43600# 0.28091f
C1140 a_154565_39260# a_154447_35509# 0.06834f
C1141 a_5347_44329# a_12894_1400# 0.02755f
C1142 a_151087_35509# a_149407_31029# 0.07446f
C1143 a_6884_34720# VDD 0.36279f
C1144 a_152740_43880# a_152767_35509# 0.03516f
C1145 a_8825_43600# a_13865_30440# 0.04212f
C1146 a_7294_26040# VDD 0.34827f
C1147 VCTRL a_151060_21760# 0.06981f
C1148 a_161285_35122# a_161140_39260# 0.05324f
C1149 a_3524_3780# VDD 1.15562f
C1150 a_5347_44329# a_3667_44329# 0.03871f
C1151 FS a_154447_35509# 0.03582f
C1152 a_154714_43820# a_154304_43820# 0.0129f
C1153 a_8564_34720# VDD 0.36293f
C1154 a_155984_39200# VDD 0.63556f
C1155 a_157664_39200# VDD 0.58394f
C1156 a_151060_30440# a_154420_35122# 0.06747f
C1157 a_152740_35122# a_161285_35122# 0.03224f
C1158 a_150944_21700# a_151060_21760# 0.01998f
C1159 a_5347_44329# a_14574_1400# 0.02312f
C1160 a_156100_30440# a_152740_43880# 0.08261f
C1161 a_121493_21789# a_136932_26600# 0.03494f
C1162 a_185244_34720# a_154565_43880# 0.01531f
C1163 a_154304_35062# a_154420_35122# 0.01149f
C1164 a_151205_35122# a_156245_39260# 0.02805f
C1165 a_15284_43540# a_13720_43600# 0.01686f
C1166 a_8680_26100# a_10654_26040# 0.01988f
C1167 a_138745_34982# a_121493_21789# 0.02454f
C1168 a_169834_39200# a_169685_39260# 0.04971f
C1169 a_154565_39260# a_157780_39260# 1.2323f
C1170 a_10360_43600# a_12334_43540# 0.02878f
C1171 a_161140_39260# a_162965_39260# 0.43049f
C1172 a_152740_35122# a_152624_35062# 0.01149f
C1173 a_152885_39260# a_154447_35509# 0.03509f
C1174 a_151087_22349# a_169685_39260# 0.27199f
C1175 a_152740_35122# a_162965_39260# 0.02873f
C1176 a_24094_26040# VDD 0.35048f
C1177 a_166325_35122# a_166474_35062# 0.01638f
C1178 a_149407_31029# a_162965_39260# 0.03057f
C1179 a_3667_35369# PB 0.07391f
C1180 NB VDD 2.33533f
C1181 a_153034_43820# a_152740_43880# 0.01619f
C1182 a_166325_35122# a_152740_43880# 0.03792f
C1183 a_152885_21760# a_169685_39260# 0.30112f
C1184 a_151205_35122# a_149407_35509# 0.03341f
C1185 VCTRL a_154420_35122# 0.0354f
C1186 a_152740_35122# a_177824_43820# 0.01162f
C1187 a_3785_26100# a_7294_26040# 0.02251f
C1188 FB ICP2 0.04359f
C1189 a_167744_39200# a_162965_39260# 0.01281f
C1190 a_151205_26100# a_151060_21760# 0.36648f
C1191 a_3785_26100# a_8564_39060# 0.01154f
C1192 a_159344_35062# a_149380_39260# 0.01536f
C1193 PB a_5465_21760# 0.04198f
C1194 a_5614_34720# VDD 0.34967f
C1195 a_6884_26040# VDD 0.3628f
C1196 a_7294_34720# VDD 0.34967f
C1197 a_151087_22349# a_149380_39260# 0.02194f
C1198 a_3785_26100# a_8680_26100# 0.02602f
C1199 a_154714_39200# VDD 0.59998f
C1200 a_3785_3840# VDD 2.25408f
C1201 a_169685_35122# VCTRL 0.02927f
C1202 a_121493_21789# a_123480_21999# 0.24141f
C1203 a_183974_34720# a_154565_43880# 0.02665f
C1204 a_159605_30440# a_157925_30440# 0.13313f
C1205 a_151205_35122# a_171220_35122# 0.02805f
C1206 a_10244_43540# a_8680_43600# 0.01745f
C1207 a_8974_43540# a_8825_43600# 0.03409f
C1208 a_169834_39200# a_169424_39200# 0.0129f
C1209 a_123480_21999# a_124836_21939# 0.11329f
C1210 a_12627_2049# a_14307_2049# 0.62167f
C1211 a_159605_30440# a_154565_30440# 0.14063f
C1212 a_10654_39060# a_8680_39120# 0.02878f
C1213 a_23684_26040# VDD 0.36279f
C1214 a_3785_26100# NB 0.06979f
C1215 a_121493_21789# a_129608_26600# 0.04562f
C1216 a_159605_30440# a_152767_35509# 0.08231f
C1217 a_154447_40129# a_149407_40129# 0.35462f
C1218 a_12627_2049# a_15987_2189# 0.18278f
C1219 a_151205_26100# a_154420_35122# 0.11712f
C1220 a_153034_43820# a_152624_43820# 0.0129f
C1221 a_149407_26689# a_152740_43880# 0.03602f
C1222 PB a_12185_21760# 0.03998f
C1223 a_19054_30380# VDD 0.34827f
C1224 a_169567_35509# a_152767_35509# 1.06305f
C1225 a_159605_30440# a_156100_30440# 2.37732f
C1226 a_179914_30380# a_151087_35509# 0.01992f
C1227 a_157925_30440# a_161140_39260# 0.02622f
C1228 a_8680_26100# a_3785_21760# 0.2529f
C1229 a_154447_35509# a_149525_26100# 0.21378f
C1230 a_152740_35122# a_157925_30440# 0.05292f
C1231 a_169567_35509# a_156100_30440# 0.04302f
C1232 a_3640_39120# FB 0.13662f
C1233 a_161140_39260# a_154565_30440# 0.10253f
C1234 VCTRL ICP2 0.04359f
C1235 PB a_5347_22349# 0.04359f
C1236 a_157925_30440# a_149407_31029# 0.02929f
C1237 a_24094_26040# a_3785_21760# 0.01998f
C1238 a_149407_40129# a_151060_21760# 0.14878f
C1239 a_161140_39260# a_152767_35509# 0.05822f
C1240 a_152740_35122# a_154565_30440# 0.06503f
C1241 a_151205_35122# VDD 0.78284f
C1242 a_121493_21789# a_133241_26660# 0.20387f
C1243 a_3640_43600# a_3667_44329# 0.08183f
C1244 a_8974_43540# a_8680_43600# 0.01038f
C1245 a_149407_31029# a_154565_30440# 0.02568f
C1246 a_139520_26600# a_122881_26660# 0.06035f
C1247 a_152740_35122# a_152767_35509# 0.35045f
C1248 a_154714_39200# a_154565_39260# 0.04904f
C1249 a_159605_30440# a_166325_35122# 0.11156f
C1250 NB a_3785_21760# 0.03849f
C1251 a_156245_39260# a_149380_39260# 0.39878f
C1252 a_123480_21999# a_123769_21999# 0.57945f
C1253 a_122881_26660# ICP2 0.03118f
C1254 a_156100_30440# a_161140_39260# 0.05763f
C1255 a_149407_31029# a_152767_35509# 0.07102f
C1256 a_22004_26040# VDD 0.36272f
C1257 a_166325_35122# a_168154_39200# 0.05434f
C1258 a_22120_39120# a_3785_26100# 0.08298f
C1259 a_10244_39060# a_8680_39120# 0.01037f
C1260 a_154447_40129# a_164645_35122# 0.02417f
C1261 a_152740_35122# a_156100_30440# 0.06158f
C1262 a_169567_35509# a_166325_35122# 0.42064f
C1263 a_159605_30440# a_151205_39260# 0.04208f
C1264 a_149380_35122# a_154447_35509# 0.03856f
C1265 a_156100_30440# a_149407_31029# 0.02568f
C1266 a_171104_39200# a_171514_39200# 0.0129f
C1267 a_171220_35122# a_169685_39260# 0.3152f
C1268 a_151087_35509# a_154565_43880# 0.03898f
C1269 a_168154_30380# VDD 0.34107f
C1270 a_3785_21760# a_7294_39060# 0.02878f
C1271 a_7000_39120# a_8564_39060# 0.01745f
C1272 a_18644_30380# VDD 0.3627f
C1273 a_13604_34720# VDD 0.3627f
C1274 a_169685_39260# a_178234_26040# 0.02481f
C1275 a_3667_35369# FB 0.21498f
C1276 a_179504_30380# a_151087_35509# 0.0106f
C1277 a_149407_35509# a_149380_39260# 0.04015f
C1278 a_3785_43600# PB 0.07862f
C1279 a_149407_40129# a_154420_35122# 0.03953f
C1280 a_166064_26040# a_157780_39260# 0.01021f
C1281 a_5347_44329# REFCK 0.51943f
C1282 a_3667_35369# a_5347_44329# 0.60545f
C1283 a_149380_35122# a_157780_39260# 0.90632f
C1284 a_166325_35122# a_152740_35122# 0.02568f
C1285 FB a_5465_21760# 0.08072f
C1286 a_164645_35122# a_151060_21760# 0.02521f
C1287 a_23684_26040# a_3785_21760# 0.01198f
C1288 a_166325_35122# a_149407_31029# 0.06876f
C1289 a_151205_39260# a_161140_39260# 0.84347f
C1290 a_15545_21760# NB 0.03849f
C1291 VDD a_149674_39200# 0.58342f
C1292 a_121880_21939# VDD 0.58027f
C1293 a_156394_35062# a_151205_26100# 0.01179f
C1294 a_5347_44329# a_5465_21760# 0.04193f
C1295 a_121100_21999# a_122881_26660# 1.88852f
C1296 a_176144_43820# a_152767_35509# 0.01279f
C1297 a_154714_39200# a_154304_39200# 0.0129f
C1298 a_10244_34720# VDD 0.36279f
C1299 a_159605_30440# a_149407_26689# 0.08192f
C1300 a_5204_3780# VDD 1.15496f
C1301 a_151205_35122# a_154565_39260# 0.0303f
C1302 a_123480_21999# a_123220_21939# 0.09314f
C1303 a_20440_43600# a_22414_43540# 0.02878f
C1304 a_152740_35122# a_151205_39260# 0.03168f
C1305 a_121869_26660# ICP2 0.03607f
C1306 a_20734_26040# VDD 0.34888f
C1307 PB a_3667_31029# 0.03851f
C1308 a_151205_39260# a_149407_31029# 0.07364f
C1309 a_151205_35122# FS 0.06876f
C1310 a_169567_35509# a_149407_26689# 0.03557f
C1311 a_188604_34720# a_154565_43880# 0.01268f
C1312 a_13865_21760# NB 0.03849f
C1313 a_169685_39260# VDD 3.4157f
C1314 a_171104_39200# a_151087_22349# 0.01342f
C1315 a_131180_21760# ICP2 0.06267f
C1316 a_7000_39120# a_7294_39060# 0.0133f
C1317 a_167744_30380# VDD 0.33892f
C1318 a_149264_39200# VDD 0.58576f
C1319 a_152740_43880# a_164645_30440# 0.03518f
C1320 a_161024_30380# a_156100_30440# 0.02537f
C1321 a_12334_34720# VDD 0.34827f
C1322 a_151087_22349# a_171514_39200# 0.05313f
C1323 a_151205_35122# a_152885_39260# 0.0303f
C1324 a_176554_43820# VDD 0.58576f
C1325 FB a_12185_21760# 0.08202f
C1326 a_164645_35122# a_154420_35122# 0.02484f
C1327 a_140574_34580# VDD 0.34888f
C1328 a_149407_26689# a_161140_39260# 0.03706f
C1329 a_164794_26040# a_157780_39260# 0.01516f
C1330 a_190284_34720# a_149407_31029# 0.01109f
C1331 a_12627_2049# a_19204_1742# 0.01284f
C1332 a_5347_44329# a_12185_21760# 0.04223f
C1333 a_149407_26689# a_152740_35122# 0.88203f
C1334 a_22004_26040# a_3785_21760# 0.01236f
C1335 a_8825_43600# a_15284_34720# 0.0104f
C1336 VDD a_182864_43820# 0.63502f
C1337 a_149407_26689# a_149407_31029# 0.36409f
C1338 VDD a_149380_39260# 2.8232f
C1339 FB a_5347_22349# 0.51431f
C1340 a_169685_35122# a_164645_35122# 0.2458f
C1341 a_120984_21939# VDD 0.5795f
C1342 a_121100_21999# a_121869_26660# 0.46839f
C1343 a_8974_34720# VDD 0.34967f
C1344 a_156394_26040# a_151205_39260# 0.02332f
C1345 a_3934_3780# VDD 1.08918f
C1346 a_152740_43880# FB 0.0712f
C1347 a_183125_39602# a_152740_43880# 0.35572f
C1348 a_20324_26040# VDD 0.3627f
C1349 NB a_3667_26689# 1.91401f
C1350 a_5347_44329# a_5347_22349# 0.0411f
C1351 a_8564_3780# a_8974_3780# 0.0129f
C1352 a_169424_39200# VDD 0.63502f
C1353 a_157780_39260# a_159754_39200# 0.0107f
C1354 a_121493_21789# a_129500_21760# 0.24433f
C1355 a_157925_30440# a_154565_43880# 0.11814f
C1356 a_151060_30440# a_152740_43880# 6.07258f
C1357 a_169685_39260# FS 0.0818f
C1358 a_164384_26040# a_157780_39260# 0.02231f
C1359 a_20734_30380# VDD 0.34827f
C1360 a_8825_43600# VDD 3.97147f
C1361 a_12627_2049# a_17934_1742# 0.01772f
C1362 a_154565_43880# a_154565_30440# 0.0804f
C1363 a_3785_43600# FB 0.14277f
C1364 a_20734_26040# a_3785_21760# 0.01133f
C1365 VDD a_181594_43820# 0.60458f
C1366 a_8825_43600# a_14014_34720# 0.02077f
C1367 a_5614_3780# VDD 1.08855f
C1368 a_152885_21760# a_151087_22349# 0.03791f
C1369 a_22414_30380# VDD 0.34827f
C1370 a_181594_26040# a_171220_35122# 0.01516f
C1371 a_190694_34720# a_149407_31029# 0.01991f
C1372 a_154565_43880# a_152767_35509# 0.03936f
C1373 a_3785_43600# a_5347_44329# 0.70619f
C1374 a_159605_30440# a_164645_30440# 0.04223f
C1375 a_164794_35062# a_164645_35122# 0.01529f
C1376 a_159605_39260# a_154447_35509# 0.17332f
C1377 a_169685_35122# a_184954_26040# 0.02929f
C1378 a_159344_43820# a_159754_43820# 0.0129f
C1379 a_132734_34580# a_121493_21789# 0.0245f
C1380 a_151205_35122# a_149525_26100# 0.03341f
C1381 a_156100_30440# a_154565_43880# 0.06813f
C1382 a_154565_39260# a_149380_39260# 0.06878f
C1383 a_151087_35509# a_154447_35509# 0.39109f
C1384 a_151060_21760# a_176554_39200# 0.0134f
C1385 a_13865_21760# a_13720_30440# 0.03849f
C1386 a_169567_35509# a_164645_30440# 0.06088f
C1387 a_18760_43600# a_5347_22349# 0.0913f
C1388 FB a_3667_31029# 0.77526f
C1389 a_157780_39260# a_159605_39260# 0.82627f
C1390 REFCK_O VDD 1.0427f
C1391 a_5347_44329# a_3667_31029# 0.11032f
C1392 a_121493_21789# a_131280_26600# 0.03494f
C1393 a_151087_35509# a_157780_39260# 0.03407f
C1394 a_154447_40129# a_151060_21760# 0.0778f
C1395 a_152885_39260# a_149380_39260# 1.04521f
C1396 PB a_123480_21999# 0.10228f
C1397 a_161140_39260# a_164645_30440# 0.03124f
C1398 a_166325_35122# a_154565_43880# 0.0848f
C1399 a_20324_30380# VDD 0.3627f
C1400 a_159605_30440# FB 0.04603f
C1401 a_159605_30440# a_183125_39602# 0.4342f
C1402 a_6780_9484# a_3667_5549# 0.08399f
C1403 a_152740_35122# a_164645_30440# 0.03057f
C1404 a_151087_22349# a_156245_39260# 0.11148f
C1405 a_20324_26040# a_3785_21760# 0.01189f
C1406 a_151205_35122# a_149380_35122# 0.18903f
C1407 a_13865_30440# VDD 2.61407f
C1408 a_22004_30380# VDD 0.3627f
C1409 a_154447_35509# a_162965_39260# 0.17093f
C1410 a_149407_31029# a_164645_30440# 0.03124f
C1411 a_161285_35122# a_157780_39260# 0.55069f
C1412 a_169567_35509# FB 0.04322f
C1413 a_156245_39260# a_156394_39200# 0.04658f
C1414 a_181184_43820# a_154447_40129# 0.01259f
C1415 a_152885_21760# a_156245_39260# 0.03557f
C1416 a_13720_30440# a_3667_26689# 0.06281f
C1417 a_132324_34580# a_121493_21789# 0.01045f
C1418 a_181184_39200# a_152885_21760# 0.01771f
C1419 a_3934_43540# a_3640_43600# 0.01038f
C1420 a_17524_1742# VDD 0.22416f
C1421 a_169424_43820# VDD 0.63502f
C1422 a_149674_39200# a_149525_26100# 0.04956f
C1423 a_159605_30440# a_151060_30440# 0.60288f
C1424 a_157780_39260# a_162965_39260# 0.01848f
C1425 a_14307_2049# a_15987_2189# 0.24524f
C1426 a_161140_39260# FB 0.02994f
C1427 a_169567_35509# a_174874_39200# 0.04772f
C1428 a_154447_40129# a_154420_35122# 0.43063f
C1429 a_20440_43600# FB 0.04198f
C1430 a_152740_35122# FB 0.03676f
C1431 a_171104_39200# VDD 0.63738f
C1432 a_149264_35062# a_149380_35122# 0.01149f
C1433 a_8825_43600# a_3785_39120# 1.30786f
C1434 FB a_149407_31029# 0.04322f
C1435 a_183125_39602# a_149407_31029# 0.02643f
C1436 a_166325_35122# a_188314_43820# 0.05016f
C1437 a_149407_26689# a_154565_43880# 0.03651f
C1438 a_171514_39200# VDD 0.60222f
C1439 a_176554_26040# VDD 0.3412f
C1440 a_169834_26040# VDD 0.34168f
C1441 a_171220_35122# a_151087_22349# 0.94593f
C1442 a_154420_35122# a_179914_43820# 0.01648f
C1443 a_169685_35122# a_154447_40129# 0.02417f
C1444 PB a_5347_39849# 0.03998f
C1445 REFCK_O FS 1.43538f
C1446 a_159605_30440# VCTRL 0.0303f
C1447 a_8680_39120# a_8564_39060# 0.02865f
C1448 a_154420_35122# a_151060_21760# 0.15924f
C1449 a_152740_35122# a_151060_30440# 0.05607f
C1450 a_159754_30380# VDD 0.34678f
C1451 a_152885_21760# a_171220_35122# 0.03741f
C1452 a_149407_35509# a_161434_43820# 0.04233f
C1453 a_151060_30440# a_149407_31029# 0.7462f
C1454 a_169567_35509# VCTRL 0.02484f
C1455 a_140864_26839# VDD 0.57875f
C1456 a_3785_43600# a_3640_43600# 0.29611f
C1457 a_121493_21789# NB 0.58544f
C1458 a_16964_43540# a_15400_43600# 0.01082f
C1459 a_168154_43820# VDD 0.58394f
C1460 a_149380_39260# a_149525_26100# 1.42076f
C1461 a_8825_43600# a_15545_21760# 0.09078f
C1462 a_169685_35122# a_151060_21760# 0.38314f
C1463 a_184544_39542# a_152740_43880# 0.01382f
C1464 a_167744_30380# a_149380_35122# 0.02493f
C1465 a_157925_30440# a_154447_35509# 0.05638f
C1466 a_174464_39200# a_174874_39200# 0.0129f
C1467 a_20324_43540# FB 0.01154f
C1468 a_149407_40129# a_152740_43880# 0.10147f
C1469 a_7294_43540# a_5320_43600# 0.02878f
C1470 VCTRL a_161140_39260# 0.02927f
C1471 a_189014_34720# a_154565_43880# 0.01988f
C1472 a_154447_35509# a_154565_30440# 0.05881f
C1473 a_149407_35509# a_156245_39260# 0.04223f
C1474 a_169834_39200# VDD 0.60202f
C1475 a_8680_43600# a_3785_39120# 0.07821f
C1476 a_10654_30380# a_3667_31029# 0.02254f
C1477 a_14307_2049# a_19614_1742# 0.01149f
C1478 a_13865_21760# a_8825_43600# 0.07378f
C1479 a_152740_35122# VCTRL 0.03849f
C1480 a_3785_39120# a_13865_30440# 0.04551f
C1481 a_154447_35509# a_152767_35509# 1.30604f
C1482 a_151087_22349# VDD 3.52139f
C1483 a_138624_26600# a_121100_21999# 0.01231f
C1484 a_20440_43600# a_18760_43600# 0.26266f
C1485 a_169424_26040# VDD 0.33892f
C1486 a_140164_34580# VDD 0.36282f
C1487 a_172784_39200# a_151087_22349# 0.01202f
C1488 VCTRL a_149407_31029# 0.04777f
C1489 a_157925_30440# a_157780_39260# 0.02011f
C1490 a_186634_26040# VDD 0.34201f
C1491 a_149380_35122# a_149380_39260# 0.0362f
C1492 a_156100_30440# a_154447_35509# 0.06137f
C1493 a_156394_39200# VDD 0.59966f
C1494 a_157780_39260# a_154565_30440# 1.04604f
C1495 a_152885_21760# VDD 3.80464f
C1496 a_8825_43600# a_15694_34720# 0.02286f
C1497 a_157780_39260# a_152767_35509# 0.03421f
C1498 a_159344_30380# VDD 0.36495f
C1499 a_10654_34720# a_3785_43600# 0.02241f
C1500 a_138745_34982# VCTRL 0.03998f
C1501 a_151060_30440# a_157664_43820# 0.01387f
C1502 a_169685_35122# a_154420_35122# 0.02927f
C1503 a_15694_43540# a_15400_43600# 0.0133f
C1504 a_153034_35062# a_151205_35122# 0.01407f
C1505 a_154714_26040# a_149525_26100# 0.02216f
C1506 a_156100_30440# a_157780_39260# 0.04338f
C1507 a_13865_30440# a_15545_21760# 0.04835f
C1508 a_157664_26040# a_151205_39260# 0.01442f
C1509 a_138745_34982# a_122881_26660# 0.26591f
C1510 a_166325_35122# a_154447_35509# 0.06639f
C1511 a_20734_30380# a_3667_26689# 0.02091f
C1512 a_161434_43820# VDD 0.60458f
C1513 a_151205_35122# a_159605_39260# 0.03488f
C1514 a_8825_43600# a_3667_26689# 0.04212f
C1515 a_152740_35122# a_151205_26100# 0.45145f
C1516 a_22414_30380# a_3667_26689# 0.02094f
C1517 a_151205_26100# a_149407_31029# 0.36522f
C1518 a_151205_35122# a_151087_35509# 0.11159f
C1519 a_154565_43880# a_164645_30440# 0.03983f
C1520 a_20324_43540# a_18760_43600# 0.01745f
C1521 a_187904_43820# VDD 0.58512f
C1522 a_13865_21760# a_13865_30440# 0.03953f
C1523 a_181594_30380# a_154447_40129# 0.02722f
C1524 a_151205_39260# a_154447_35509# 0.21697f
C1525 VDD a_12334_26040# 0.34827f
C1526 a_152740_35122# a_177824_30380# 0.02459f
C1527 a_3934_21700# VDD 0.34678f
C1528 a_156394_43820# a_154565_43880# 0.05481f
C1529 a_151087_22349# a_154565_39260# 0.01082f
C1530 a_156245_39260# VDD 2.79761f
C1531 FB a_5347_39849# 0.45783f
C1532 a_161285_35122# a_151205_35122# 0.03167f
C1533 a_181184_39200# VDD 0.6348f
C1534 a_159605_30440# a_149407_40129# 0.07348f
C1535 a_3785_43600# a_5320_43600# 0.06896f
C1536 a_159605_30440# a_188314_39542# 0.01156f
C1537 FB a_3785_30440# 0.90065f
C1538 a_5347_44329# a_5347_39849# 0.0411f
C1539 a_154565_39260# a_156394_39200# 0.01004f
C1540 a_157780_39260# a_151205_39260# 0.70712f
C1541 a_167744_39200# a_166325_39260# 0.05265f
C1542 a_7294_21700# a_5320_21760# 0.01988f
C1543 a_169567_35509# a_149407_40129# 1.44469f
C1544 a_154304_26040# a_149525_26100# 0.01109f
C1545 a_5347_44329# a_3785_30440# 0.04433f
C1546 a_151205_35122# a_162965_39260# 0.02805f
C1547 a_123480_21999# a_122881_26660# 0.23058f
C1548 a_152885_21760# FS 0.22538f
C1549 FB a_154565_43880# 0.07304f
C1550 a_183125_39602# a_154565_43880# 0.4793f
C1551 a_149407_26689# a_154447_35509# 0.04526f
C1552 a_149407_35509# VDD 4.34545f
C1553 a_13865_30440# a_3667_26689# 0.48976f
C1554 a_176144_26040# a_161140_39260# 0.0242f
C1555 a_149407_40129# a_161140_39260# 0.02419f
C1556 a_186634_43820# VDD 0.60202f
C1557 a_181184_30380# a_154447_40129# 0.014f
C1558 a_152740_35122# a_149407_40129# 0.05327f
C1559 VDD a_11924_26040# 0.3627f
C1560 a_149407_26689# a_157780_39260# 0.02414f
C1561 a_171514_26040# a_159605_39260# 0.01992f
C1562 a_151060_30440# a_154565_43880# 0.47373f
C1563 a_149407_40129# a_149407_31029# 0.09503f
C1564 a_15284_34720# VDD 0.3627f
C1565 a_171220_35122# VDD 2.22411f
C1566 a_3524_26040# VDD 0.36665f
C1567 a_159605_30440# a_164645_35122# 0.03756f
C1568 a_172784_39200# a_171220_35122# 0.05274f
C1569 a_169685_39260# a_151087_35509# 0.14838f
C1570 a_154565_39260# a_156245_39260# 0.88454f
C1571 a_169424_43820# a_149380_35122# 0.01279f
C1572 a_18760_43600# a_20734_43540# 0.02882f
C1573 a_133241_26660# a_122881_26660# 0.03879f
C1574 a_123480_21999# a_121869_26660# 0.13648f
C1575 a_3640_39120# a_3667_44329# 0.10985f
C1576 VDD a_166064_43820# 0.63246f
C1577 a_3934_21700# a_3785_21760# 0.02481f
C1578 a_13604_21700# a_12185_21760# 0.01071f
C1579 a_152885_39260# a_156245_39260# 0.26741f
C1580 a_3934_30380# a_3785_30440# 0.02332f
C1581 a_161140_39260# a_164645_35122# 1.61879f
C1582 a_153034_30380# a_149407_35509# 0.02665f
C1583 a_149407_35509# a_154565_39260# 0.03557f
C1584 a_129608_26600# a_121869_26660# 0.01599f
C1585 a_151087_35509# a_149380_39260# 0.04359f
C1586 a_152740_35122# a_164645_35122# 0.02681f
C1587 a_8564_21700# a_5465_21760# 0.01113f
C1588 a_151205_35122# a_157925_30440# 0.02659f
C1589 a_149407_31029# a_164645_35122# 0.02864f
C1590 a_172784_39200# VDD 0.58276f
C1591 a_14014_34720# VDD 0.34827f
C1592 a_151205_35122# a_154565_30440# 0.0303f
C1593 NB a_34200_21944# 0.03416f
C1594 a_151205_35122# a_152767_35509# 0.07843f
C1595 a_168154_43820# a_149380_35122# 0.01505f
C1596 a_121100_21999# ICP2 0.03124f
C1597 a_152885_39260# a_149407_35509# 0.03582f
C1598 a_154447_40129# a_152740_43880# 0.03412f
C1599 a_3667_35369# a_3667_44329# 0.54525f
C1600 a_171220_35122# FS 0.08108f
C1601 a_133241_26660# a_121869_26660# 0.04165f
C1602 a_151205_35122# a_156100_30440# 0.02659f
C1603 VDD a_164794_43820# 0.58576f
C1604 a_154447_35509# a_164645_30440# 0.18779f
C1605 a_5465_21760# a_3667_44329# 0.04519f
C1606 a_153034_39200# VDD 0.59998f
C1607 a_131180_21760# a_133241_26660# 0.35841f
C1608 a_3785_26100# VDD 5.55481f
C1609 a_152740_43880# a_151060_21760# 0.84939f
C1610 PB NB 0.69081f
C1611 a_169685_35122# a_169834_35062# 0.01386f
C1612 a_154565_39260# VDD 3.57721f
C1613 a_168154_43820# a_167744_43820# 0.0129f
C1614 FB a_154447_35509# 0.04359f
C1615 a_151205_35122# a_151205_39260# 0.03167f
C1616 VDD FS 3.87058f
C1617 a_169685_39260# a_157925_30440# 1.28699f
C1618 a_178234_39200# FB 0.04971f
C1619 a_12185_21760# a_3667_44329# 0.07092f
C1620 a_159605_30440# a_189994_39542# 0.01149f
C1621 a_169567_35509# a_184544_26040# 0.0126f
C1622 a_171104_26040# a_159605_39260# 0.01418f
C1623 a_169685_39260# a_154565_30440# 1.22114f
C1624 a_3934_43540# a_3667_44329# 0.01188f
C1625 VDD a_3785_21760# 4.84251f
C1626 a_152885_39260# VDD 2.92952f
C1627 a_157780_39260# FB 0.0364f
C1628 a_3785_3840# a_6780_9484# 0.01027f
C1629 a_169685_39260# a_152767_35509# 0.15989f
C1630 a_152740_43880# a_154420_35122# 0.04386f
C1631 a_169567_35509# a_176554_39200# 0.05355f
C1632 a_151060_30440# a_154447_35509# 0.03311f
C1633 a_5347_22349# a_3667_44329# 0.03933f
C1634 a_149407_40129# a_154565_43880# 0.06576f
C1635 a_3785_39120# VDD 0.30438f
C1636 a_8825_43600# a_15400_43600# 0.08775f
C1637 a_149407_35509# a_149525_26100# 0.11413f
C1638 a_159605_30440# a_154447_40129# 0.3619f
C1639 a_156100_30440# a_169685_39260# 0.04822f
C1640 a_22120_39120# a_22414_39060# 0.01069f
C1641 a_149380_35122# a_156245_39260# 0.06358f
C1642 a_149407_26689# a_151205_35122# 0.07099f
C1643 a_157925_30440# a_149380_39260# 0.09727f
C1644 a_162704_35062# a_157780_39260# 0.01161f
C1645 a_155984_43820# VDD 0.58512f
C1646 a_14014_26040# a_5347_39849# 0.0215f
C1647 a_129500_21760# a_122881_26660# 1.75866f
C1648 a_169567_35509# a_154447_40129# 0.02657f
C1649 VDD a_151354_26040# 0.34727f
C1650 a_154304_39200# VDD 0.63738f
C1651 a_149380_39260# a_154565_30440# 0.02915f
C1652 VDD a_189994_43820# 0.60458f
C1653 a_152885_39260# a_153034_39200# 0.04988f
C1654 a_152767_35509# a_149380_39260# 0.04007f
C1655 a_20734_34720# VDD 0.34827f
C1656 a_3785_26100# a_3785_21760# 0.57285f
C1657 VCTRL a_154447_35509# 0.0303f
C1658 a_166325_35122# a_169685_39260# 0.08509f
C1659 a_159605_30440# a_151060_21760# 0.07792f
C1660 a_149407_35509# a_149380_35122# 0.22743f
C1661 a_154447_40129# a_161140_39260# 0.02417f
C1662 a_15545_21760# VDD 2.35422f
C1663 a_156100_30440# a_149380_39260# 0.03791f
C1664 a_3785_43600# a_3667_44329# 0.54303f
C1665 a_8825_43600# a_10360_43600# 0.06658f
C1666 a_3785_39120# a_3785_26100# 0.29336f
C1667 a_8680_43600# a_10654_43540# 0.02878f
C1668 a_152740_35122# a_154447_40129# 0.16566f
C1669 a_3524_39060# a_3640_39120# 0.02888f
C1670 a_169567_35509# a_151060_21760# 0.63087f
C1671 a_12334_21700# a_12185_21760# 0.02648f
C1672 a_169685_39260# a_151205_39260# 0.0922f
C1673 a_154447_40129# a_149407_31029# 0.10534f
C1674 a_159344_26040# a_149380_39260# 0.02623f
C1675 VCTRL a_157780_39260# 0.02484f
C1676 a_8825_43600# a_15284_43540# 0.01078f
C1677 a_13865_21760# VDD 2.84692f
C1678 a_5320_21760# a_3785_21760# 0.03996f
C1679 a_161285_35122# a_169834_26040# 0.01988f
C1680 a_174464_43820# a_154447_35509# 0.01106f
C1681 a_154714_43820# VDD 0.59998f
C1682 a_161140_39260# a_151060_21760# 1.44607f
C1683 a_129500_21760# a_121869_26660# 0.3507f
C1684 a_3667_31029# a_3667_44329# 0.04457f
C1685 a_173194_26040# a_162965_39260# 0.02665f
C1686 NB FB 0.11592f
C1687 VDD a_149525_26100# 4.1402f
C1688 a_10244_21700# a_5465_21760# 0.01113f
C1689 a_152740_35122# a_151060_21760# 1.69184f
C1690 a_15694_34720# VDD 0.34827f
C1691 a_159605_30440# a_154420_35122# 0.06372f
C1692 a_3785_21760# a_17374_26040# 0.01133f
C1693 a_3667_35369# a_17374_34720# 0.02091f
C1694 a_3785_26100# a_15545_21760# 0.03754f
C1695 a_149407_31029# a_151060_21760# 0.34973f
C1696 a_151205_39260# a_149380_39260# 0.69647f
C1697 a_5347_44329# NB 0.04359f
C1698 a_20324_34720# VDD 0.3627f
C1699 a_151087_22349# a_159605_39260# 0.08207f
C1700 a_131180_21760# a_129500_21760# 0.01215f
C1701 a_3785_26100# a_7000_39120# 0.13104f
C1702 a_149407_26689# a_169685_39260# 0.0399f
C1703 a_169567_35509# a_154420_35122# 0.02718f
C1704 a_3667_35369# a_5465_21760# 0.08066f
C1705 a_151087_22349# a_151087_35509# 0.04176f
C1706 a_5204_21700# a_5320_21760# 0.01998f
C1707 a_8680_43600# a_10360_43600# 0.2601f
C1708 a_13865_21760# a_3785_26100# 0.03791f
C1709 a_3667_26689# VDD 5.36487f
C1710 VDD a_171514_43820# 0.60458f
C1711 a_152885_21760# a_151087_35509# 0.09871f
C1712 a_169685_35122# a_169567_35509# 0.45694f
C1713 a_149380_35122# VDD 2.82721f
C1714 a_161140_39260# a_154420_35122# 0.07741f
C1715 a_10654_21700# a_5465_21760# 0.0228f
C1716 a_17374_43540# a_15400_43600# 0.02878f
C1717 a_173194_43820# a_154447_35509# 0.04757f
C1718 a_10244_43540# a_10360_43600# 0.02865f
C1719 a_151205_35122# a_164645_30440# 0.0303f
C1720 a_152740_35122# a_154420_35122# 0.33735f
C1721 a_15545_21760# a_15694_39402# 0.01511f
C1722 a_149407_26689# a_149380_39260# 0.33102f
C1723 a_149407_31029# a_154420_35122# 0.06291f
C1724 a_15545_21760# a_3785_21760# 0.03794f
C1725 a_185244_34720# VDD 0.36391f
C1726 a_8974_21700# a_5465_21760# 0.0228f
C1727 a_151087_22349# a_162965_39260# 0.0481f
C1728 a_7000_39120# a_3785_21760# 0.23634f
C1729 a_143104_26600# a_129500_21760# 0.02424f
C1730 a_169685_35122# a_161140_39260# 1.15663f
C1731 a_3667_35369# a_12185_21760# 0.07558f
C1732 a_3667_35369# a_17080_34780# 0.18872f
C1733 NB VCTRL 0.12618f
C1734 a_169685_35122# a_152740_35122# 0.03013f
C1735 a_154565_39260# a_149525_26100# 0.26256f
C1736 a_12185_21760# a_12334_39402# 0.01732f
C1737 a_183274_43820# a_182864_43820# 0.0129f
C1738 a_13865_21760# a_3785_21760# 0.03849f
C1739 a_152885_21760# a_162965_39260# 0.0418f
C1740 a_3785_26100# a_3667_26689# 2.76471f
C1741 a_149407_40129# a_154447_35509# 0.29522f
C1742 a_5465_21760# a_12185_21760# 0.05505f
C1743 a_168154_26040# VDD 0.34666f
C1744 a_156245_39260# a_159605_39260# 0.30091f
C1745 a_3667_35369# a_5347_22349# 0.0418f
C1746 NB a_122881_26660# 0.05145f
C1747 a_151087_35509# a_156245_39260# 0.05662f
C1748 VDD a_171104_43820# 0.63244f
C1749 a_167744_43820# VDD 0.58253f
C1750 a_152885_39260# a_149525_26100# 0.09529f
C1751 a_149407_40129# a_157780_39260# 0.02968f
C1752 a_173194_43820# a_172784_43820# 0.0129f
C1753 VDD a_19054_26040# 0.34888f
C1754 a_5465_21760# a_5347_22349# 0.64139f
C1755 a_154565_39260# a_149380_35122# 0.06763f
C1756 a_169834_30380# a_154447_35509# 0.02332f
C1757 a_161285_35122# a_156245_39260# 0.10559f
C1758 a_149407_35509# a_159605_39260# 0.03124f
C1759 a_3785_43600# a_8564_43540# 0.0124f
C1760 a_151205_35122# a_151060_30440# 0.03527f
C1761 a_157925_30440# a_168154_43820# 0.04074f
C1762 a_151087_35509# a_149407_35509# 0.04359f
C1763 a_3667_26689# a_3785_21760# 0.3358f
C1764 a_8825_43600# PB 0.0354f
C1765 a_129794_21700# a_129500_21760# 0.01069f
C1766 a_169685_39260# a_164645_30440# 0.11274f
C1767 VDD a_153034_26040# 0.34107f
C1768 a_149525_26100# a_189994_43820# 0.04073f
C1769 a_13865_21760# a_15545_21760# 0.06497f
C1770 a_156245_39260# a_162965_39260# 0.08095f
C1771 a_3667_35369# a_3785_43600# 0.72088f
C1772 a_154447_35509# a_164645_35122# 0.03263f
C1773 a_154447_40129# a_154565_43880# 0.03888f
C1774 a_159754_39200# VDD 0.59966f
C1775 a_3785_39120# a_3667_26689# 0.46888f
C1776 a_152885_39260# a_149380_35122# 0.03219f
C1777 a_22414_34720# VDD 0.34888f
C1778 a_167744_26040# VDD 0.36391f
C1779 a_138745_34982# ICP2 0.19484f
C1780 NB a_121869_26660# 0.05973f
C1781 a_151087_22349# a_157925_30440# 0.09879f
C1782 a_5347_22349# a_12185_21760# 0.10859f
C1783 a_171220_35122# a_151087_35509# 0.04359f
C1784 a_3785_43600# a_5465_21760# 0.06694f
C1785 a_173194_39200# a_171220_35122# 0.01554f
C1786 a_10244_30380# VDD 0.36341f
C1787 a_151205_35122# VCTRL 0.03167f
C1788 a_172784_35062# a_151060_21760# 0.01186f
C1789 VDD a_18644_26040# 0.3627f
C1790 a_151087_22349# a_152767_35509# 0.06679f
C1791 a_3667_35369# a_3667_31029# 0.03593f
C1792 a_178234_30380# a_151205_35122# 0.01988f
C1793 a_159344_30380# a_157925_30440# 0.011f
C1794 a_154565_43880# a_151060_21760# 0.04939f
C1795 a_169685_39260# FB 0.04359f
C1796 REFCK_O a_33194_4122# 0.01511f
C1797 a_176284_34720# VDD 0.49859f
C1798 a_156100_30440# a_151087_22349# 0.04813f
C1799 a_15545_21760# a_3667_26689# 0.06775f
C1800 a_159754_35062# a_152885_39260# 0.01344f
C1801 a_164384_35062# a_161140_39260# 0.01161f
C1802 a_18644_21700# VDD 0.36569f
C1803 a_152885_21760# a_152767_35509# 0.14221f
C1804 a_3667_31029# a_5465_21760# 0.05069f
C1805 VDD a_163114_39200# 0.59998f
C1806 VDD a_152624_26040# 0.33963f
C1807 a_171220_35122# a_162965_39260# 0.10848f
C1808 a_121100_21999# a_136932_26600# 0.01116f
C1809 a_3667_26689# a_19054_43540# 0.03479f
C1810 a_13865_30440# PB 0.04359f
C1811 a_159605_39260# VDD 2.93375f
C1812 a_152885_21760# a_156100_30440# 0.95497f
C1813 a_3785_43600# a_12185_21760# 0.03557f
C1814 a_138745_34982# a_121100_21999# 0.27215f
C1815 a_17080_34780# a_3785_43600# 0.07907f
C1816 a_22004_34720# VDD 0.36272f
C1817 a_13865_21760# a_3667_26689# 0.03791f
C1818 a_151087_35509# VDD 5.02894f
C1819 a_3667_44329# a_5347_39849# 0.06203f
C1820 a_15694_30380# a_13720_30440# 0.01988f
C1821 a_121493_21789# VDD 4.58056f
C1822 a_173194_39200# VDD 0.58394f
C1823 a_151205_26100# a_151205_35122# 0.06588f
C1824 a_3785_43600# a_3934_43540# 0.03452f
C1825 FB a_149380_39260# 0.04359f
C1826 a_166325_35122# a_151087_22349# 0.0628f
C1827 a_8974_30380# VDD 0.34888f
C1828 a_173194_39200# a_172784_39200# 0.0129f
C1829 a_13720_43600# a_5347_22349# 0.15071f
C1830 a_3667_44329# a_3785_30440# 0.01744f
C1831 a_154565_43880# a_154420_35122# 0.0452f
C1832 a_3785_43600# a_5347_22349# 0.1653f
C1833 a_157925_30440# a_156245_39260# 0.02568f
C1834 a_179504_30380# a_154420_35122# 0.01998f
C1835 a_3785_26100# a_24094_43540# 0.02878f
C1836 a_161285_35122# VDD 1.20757f
C1837 a_166325_35122# a_152885_21760# 0.02219f
C1838 a_151087_22349# a_151205_39260# 0.04958f
C1839 a_3667_31029# a_12185_21760# 0.08816f
C1840 a_149380_35122# a_149525_26100# 0.07302f
C1841 a_156245_39260# a_154565_30440# 0.09334f
C1842 a_14014_43540# a_13720_43600# 0.01363f
C1843 a_156245_39260# a_152767_35509# 0.04143f
C1844 a_151060_30440# a_149380_39260# 0.04193f
C1845 a_169685_39260# VCTRL 1.02977f
C1846 a_169424_43820# a_169834_43820# 0.0129f
R0 VCTRL VCTRL.n0 316.329
R1 VCTRL.n0 VCTRL.t0 32.2628
R2 VCTRL.n0 VCTRL.t1 9.25587
R3 NB NB.n8 260.873
R4 NB.n0 NB.t0 36.0256
R5 NB.n4 NB.t9 36.0256
R6 NB.n3 NB.n2 21.4256
R7 NB.n2 NB.n1 21.4256
R8 NB.n1 NB.n0 21.4256
R9 NB.n7 NB.n6 21.4256
R10 NB.n6 NB.n5 21.4256
R11 NB.n5 NB.n4 21.4256
R12 NB.n3 NB.t4 14.6005
R13 NB.n2 NB.t3 14.6005
R14 NB.n1 NB.t2 14.6005
R15 NB.n0 NB.t1 14.6005
R16 NB.n7 NB.t5 14.6005
R17 NB.n6 NB.t6 14.6005
R18 NB.n5 NB.t7 14.6005
R19 NB.n4 NB.t8 14.6005
R20 NB.n8 NB.n3 10.7131
R21 NB.n8 NB.n7 10.7131
R22 PB PB.n14 236.537
R23 PB.n0 PB.t0 36.0256
R24 PB.n7 PB.t15 36.0256
R25 PB.n6 PB.n5 21.4256
R26 PB.n5 PB.n4 21.4256
R27 PB.n4 PB.n3 21.4256
R28 PB.n3 PB.n2 21.4256
R29 PB.n2 PB.n1 21.4256
R30 PB.n1 PB.n0 21.4256
R31 PB.n13 PB.n12 21.4256
R32 PB.n12 PB.n11 21.4256
R33 PB.n11 PB.n10 21.4256
R34 PB.n10 PB.n9 21.4256
R35 PB.n9 PB.n8 21.4256
R36 PB.n8 PB.n7 21.4256
R37 PB.n6 PB.t7 14.6005
R38 PB.n5 PB.t6 14.6005
R39 PB.n4 PB.t5 14.6005
R40 PB.n3 PB.t4 14.6005
R41 PB.n2 PB.t3 14.6005
R42 PB.n1 PB.t2 14.6005
R43 PB.n0 PB.t1 14.6005
R44 PB.n13 PB.t8 14.6005
R45 PB.n12 PB.t9 14.6005
R46 PB.n11 PB.t10 14.6005
R47 PB.n10 PB.t11 14.6005
R48 PB.n9 PB.t12 14.6005
R49 PB.n8 PB.t13 14.6005
R50 PB.n7 PB.t14 14.6005
R51 PB.n14 PB.n6 10.7131
R52 PB.n14 PB.n13 10.7131
R53 ICP2 ICP2.n2 252.858
R54 ICP2.n1 ICP2.t2 72.4689
R55 ICP2.n0 ICP2.t1 56.5065
R56 ICP2.n0 ICP2.t0 56.5065
R57 ICP2.n1 ICP2.t3 48.3995
R58 ICP2.n2 ICP2.n0 31.1709
R59 ICP2.n2 ICP2.n1 18.7025
R60 FB.n5 FB.n2 306.705
R61 FB.n0 FB.t7 95.9772
R62 FB.n2 FB.t6 76.0062
R63 FB.n3 FB.t3 74.8719
R64 FB.n0 FB.t5 73.7289
R65 FB.n1 FB.t4 73.2429
R66 FB.n3 FB.t2 70.6269
R67 FB.n4 FB.n3 65.3525
R68 FB.t1 FB.n4 31.3985
R69 FB.n1 FB.n0 27.1565
R70 FB FB.n5 20.3855
R71 FB.n4 FB.t0 12.3326
R72 FB.n2 FB.n1 9.6365
R73 FB.n5 FB.t1 4.5005
R74 a_121569_21999.t0 a_121569_21999.t4 40.2778
R75 a_121569_21999.t3 a_121569_21999.t0 25.4591
R76 a_34200_24066.t4 a_34200_24066.n1 57.492
R77 a_34200_24066.n1 a_34200_24066.t5 16.6307
R78 a_34200_24066.n1 a_34200_24066.n0 13.6109
R79 a_34200_24066.t1 a_34200_24066.t4 12.3365
R80 a_34200_24066.n0 a_34200_24066.t3 10.4417
R81 a_34200_24066.n0 a_34200_24066.t2 10.0656
R82 a_34200_24066.t0 a_34200_24066.t1 8.46095
R83 a_149525_21760.t5 a_149525_21760.n0 47.1725
R84 a_149525_21760.t1 a_149525_21760.t3 28.0979
R85 a_149525_21760.t4 a_149525_21760.t5 17.7065
R86 a_149525_21760.n0 a_149525_21760.t0 9.33865
R87 a_149525_21760.t3 a_149525_21760.t4 6.9065
R88 a_149525_21760.n0 a_149525_21760.t2 6.82037
R89 a_20585_21760.t1 a_20585_21760.n0 217.47
R90 a_20585_21760.n0 a_20585_21760.t2 83.1489
R91 a_20585_21760.n0 a_20585_21760.t3 62.3259
R92 a_20585_21760.t0 a_20585_21760.t1 37.9924
R93 a_18905_21760.t0 a_18905_21760.n4 181.891
R94 a_18905_21760.n1 a_18905_21760.t6 72.4689
R95 a_18905_21760.n0 a_18905_21760.t2 72.2797
R96 a_18905_21760.n0 a_18905_21760.t3 72.2797
R97 a_18905_21760.n2 a_18905_21760.t4 72.2797
R98 a_18905_21760.n2 a_18905_21760.t5 72.2797
R99 a_18905_21760.n1 a_18905_21760.t7 48.3995
R100 a_18905_21760.n3 a_18905_21760.n2 39.7149
R101 a_18905_21760.n4 a_18905_21760.n3 31.0925
R102 a_18905_21760.t1 a_18905_21760.t0 29.6824
R103 a_18905_21760.n3 a_18905_21760.n1 29.5985
R104 a_18905_21760.n4 a_18905_21760.n0 6.70887
R105 a_7027_22349.t5 a_7027_22349.n0 212.587
R106 a_7027_22349.n0 a_7027_22349.t4 91.7889
R107 a_7027_22349.n0 a_7027_22349.t2 74.8029
R108 a_7027_22349.t0 a_7027_22349.t1 16.2304
R109 a_7027_22349.t3 a_7027_22349.t5 14.2565
R110 a_7027_22349.t1 a_7027_22349.t3 4.8965
R111 a_154447_26689.n0 a_154447_26689.t3 75.2919
R112 a_154447_26689.n0 a_154447_26689.t2 72.7029
R113 a_154447_26689.n1 a_154447_26689.t4 59.4146
R114 a_154447_26689.t0 a_154447_26689.n1 49.4165
R115 a_154447_26689.t5 a_154447_26689.t0 25.0325
R116 a_154447_26689.t1 a_154447_26689.t5 19.3379
R117 a_154447_26689.n1 a_154447_26689.n0 10.7765
R118 a_154565_35122.t5 a_154565_35122.t4 62.1846
R119 a_154565_35122.t2 a_154565_35122.t5 28.5245
R120 a_154565_35122.t1 a_154565_35122.t3 26.8979
R121 a_154565_35122.t3 a_154565_35122.t0 25.0565
R122 a_154565_35122.t0 a_154565_35122.t2 5.3165
R123 a_149525_35122.t0 a_149525_35122.t1 44.5446
R124 a_149525_35122.t3 a_149525_35122.t4 31.5719
R125 a_149525_35122.t4 a_149525_35122.t2 30.3725
R126 a_149525_35122.t2 a_149525_35122.t0 20.2685
R127 a_149525_30440.t2 a_149525_30440.n0 50.4665
R128 a_149525_30440.n0 a_149525_30440.t0 31.9626
R129 a_149525_30440.t3 a_149525_30440.t4 22.9919
R130 a_149525_30440.t4 a_149525_30440.t2 20.2025
R131 a_149525_30440.n0 a_149525_30440.t1 16.8086
R132 a_151087_31029.n0 a_151087_31029.t3 77.5089
R133 a_151087_31029.n0 a_151087_31029.t4 65.0765
R134 a_151087_31029.t2 a_151087_31029.t1 47.1065
R135 a_151087_31029.t5 a_151087_31029.t2 13.8365
R136 a_151087_31029.t0 a_151087_31029.t5 8.68194
R137 a_151087_31029.t1 a_151087_31029.n0 6.0665
R138 a_149525_43880.n0 a_149525_43880.t2 71.2329
R139 a_149525_43880.n1 a_149525_43880.t3 70.6269
R140 a_149525_43880.n2 a_149525_43880.t4 66.5469
R141 a_149525_43880.n0 a_149525_43880.t5 63.9146
R142 a_149525_43880.t6 a_149525_43880.n3 53.1725
R143 a_149525_43880.t1 a_149525_43880.t7 15.8639
R144 a_149525_43880.n2 a_149525_43880.t0 13.6046
R145 a_149525_43880.t7 a_149525_43880.t6 12.4565
R146 a_149525_43880.n1 a_149525_43880.n0 6.9065
R147 a_149525_43880.n3 a_149525_43880.n2 4.5005
R148 a_149525_43880.n3 a_149525_43880.n1 2.9165
R149 a_5465_3840.t0 a_5465_3840.n0 272.19
R150 a_5465_3840.n0 a_5465_3840.t2 117.409
R151 a_5465_3840.n0 a_5465_3840.t3 98.1396
R152 a_5465_3840.t1 a_5465_3840.t0 16.9978
R153 a_3667_22349.n5 a_3667_22349.t12 91.7022
R154 a_3667_22349.n2 a_3667_22349.t10 87.4572
R155 a_3667_22349.n0 a_3667_22349.t4 79.1889
R156 a_3667_22349.n6 a_3667_22349.t8 71.0919
R157 a_3667_22349.n0 a_3667_22349.t6 71.0229
R158 a_3667_22349.n1 a_3667_22349.t7 71.0229
R159 a_3667_22349.n2 a_3667_22349.t11 71.0193
R160 a_3667_22349.n5 a_3667_22349.t9 71.0193
R161 a_3667_22349.t1 a_3667_22349.t3 28.1524
R162 a_3667_22349.n3 a_3667_22349.t0 14.2841
R163 a_3667_22349.n6 a_3667_22349.n5 12.0125
R164 a_3667_22349.t2 a_3667_22349.t5 11.1965
R165 a_3667_22349.n4 a_3667_22349.n3 10.7765
R166 a_3667_22349.t5 a_3667_22349.n7 10.5665
R167 a_3667_22349.n7 a_3667_22349.n4 7.5365
R168 a_3667_22349.n3 a_3667_22349.n2 7.5365
R169 a_3667_22349.n1 a_3667_22349.n0 5.0165
R170 a_3667_22349.t3 a_3667_22349.t2 2.0765
R171 a_3667_22349.n4 a_3667_22349.n1 2.0765
R172 a_3667_22349.n7 a_3667_22349.n6 2.0765
C1847 LO VSS 8.20988f
C1848 REFCK VSS 11.602f
C1849 REFCK_O VSS 58.7067f
C1850 VCTRL VSS 86.92127f
C1851 NB VSS 77.54195f
C1852 PB VSS 59.34871f
C1853 FS VSS 7.67837f
C1854 ICP2 VSS 68.03909f
C1855 FB VSS 0.11287p
C1856 VDD VSS 1.15509p
C1857 a_19614_1742# VSS 0.24358f
C1858 a_19204_1742# VSS 0.25096f
C1859 a_17934_1742# VSS 0.02717f
C1860 a_17524_1742# VSS 0.02717f
C1861 a_16254_1742# VSS 0.24097f
C1862 a_15844_1742# VSS 0.25096f
C1863 a_15987_2189# VSS 1.73444f ; **FLOATING
C1864 a_14574_1400# VSS 0.39313f
C1865 a_14164_1400# VSS 0.40784f ; **FLOATING
C1866 a_14307_2049# VSS 1.98459f ; **FLOATING
C1867 a_12894_1400# VSS 0.04368f
C1868 a_12484_1400# VSS 0.04368f
C1869 a_12627_2049# VSS 2.31517f ; **FLOATING
C1870 a_34874_3780# VSS 0.04368f
C1871 a_34464_3780# VSS 0.04368f
C1872 a_33194_4122# VSS 0.24044f
C1873 a_32784_4122# VSS 0.2541f ; **FLOATING
C1874 a_27034_3780# VSS 0.04368f
C1875 a_26624_3780# VSS 0.04368f
C1876 a_25354_4122# VSS 0.24044f
C1877 a_25205_4182# VSS 4.27554f ; **FLOATING
C1878 a_24944_4122# VSS 0.2541f ; **FLOATING
C1879 a_8974_3780# VSS 0.67777f
C1880 a_8564_3780# VSS 0.70799f
C1881 a_7294_3780# VSS 0.67777f
C1882 a_6884_3780# VSS 0.70854f
C1883 a_5614_3780# VSS 0.13083f
C1884 a_5204_3780# VSS 0.13083f
C1885 a_3934_3780# VSS 0.13083f
C1886 a_3524_3780# VSS 0.13083f
C1887 a_8000_9484# VSS 2.63799f
C1888 a_3667_5549# VSS 9.56416f ; **FLOATING
C1889 a_3785_3840# VSS 5.40592f ; **FLOATING
C1890 a_7180_11606# VSS 0.70471f ; **FLOATING
C1891 a_6780_9484# VSS 2.63799f
C1892 a_153034_21700# VSS 0.39203f
C1893 a_152624_21700# VSS 0.41056f ; **FLOATING
C1894 a_151354_21700# VSS 0.04368f
C1895 a_150944_21700# VSS 0.04368f
C1896 a_149674_21700# VSS 0.39121f ; **FLOATING
C1897 a_149264_21700# VSS 0.41138f ; **FLOATING
C1898 a_134996_21700# VSS 0.40253f
C1899 a_134424_21700# VSS 0.40213f
C1900 a_133154_21700# VSS 0.38721f ; **FLOATING
C1901 a_132744_21700# VSS 0.38355f
C1902 a_131474_21700# VSS 0.38483f
C1903 a_131180_21760# VSS 1.2893f ; **FLOATING
C1904 a_131064_21700# VSS 0.38539f
C1905 a_129794_21700# VSS 0.38401f
C1906 a_129384_21700# VSS 0.38599f
C1907 a_127916_21700# VSS 0.1192f
C1908 a_126300_21700# VSS 0.1192f
C1909 a_124836_21939# VSS 1.18584f
C1910 a_123769_21999# VSS 0.90846f ; **FLOATING
C1911 a_123220_21939# VSS 1.18244f
C1912 a_121880_21939# VSS 0.09961f
C1913 a_120984_21939# VSS 0.09961f
C1914 a_34200_21944# VSS 0.39353p ; **FLOATING
C1915 a_20734_21700# VSS 0.04368f
C1916 a_20324_21700# VSS 0.04368f
C1917 a_19054_21700# VSS 0.04368f
C1918 a_18644_21700# VSS 0.04368f
C1919 a_17374_21700# VSS 0.04368f
C1920 a_16964_21700# VSS 0.04368f
C1921 a_15694_21700# VSS 0.04368f
C1922 a_15284_21700# VSS 0.04368f
C1923 a_14014_21700# VSS 0.04368f
C1924 a_13604_21700# VSS 0.04368f
C1925 a_12334_21700# VSS 0.04368f
C1926 a_11924_21700# VSS 0.04368f
C1927 a_10654_21700# VSS 0.04368f
C1928 a_10244_21700# VSS 0.04368f
C1929 a_8974_21700# VSS 0.04368f
C1930 a_8564_21700# VSS 0.04368f
C1931 a_7294_21700# VSS 0.39439f
C1932 a_6884_21700# VSS 0.40799f ; **FLOATING
C1933 a_5614_21700# VSS 0.38371f
C1934 a_5320_21760# VSS 0.94793f ; **FLOATING
C1935 a_5204_21700# VSS 0.38606f
C1936 a_3934_21700# VSS 0.04368f
C1937 a_3524_21700# VSS 0.04368f
C1938 a_189994_26040# VSS 0.39521f
C1939 a_189584_26040# VSS 0.40738f
C1940 a_188314_26040# VSS 0.38721f
C1941 a_187904_26040# VSS 0.38367f
C1942 a_186634_26040# VSS 0.04368f
C1943 a_186224_26040# VSS 0.04368f
C1944 a_184954_26040# VSS 0.04368f
C1945 a_184544_26040# VSS 0.04368f
C1946 a_183274_26040# VSS 0.39121f
C1947 a_182864_26040# VSS 0.41056f ; **FLOATING
C1948 a_181594_26040# VSS 0.38368f
C1949 a_181184_26040# VSS 0.38518f
C1950 a_179914_26040# VSS 0.39439f
C1951 a_179504_26040# VSS 0.40738f
C1952 a_178234_26040# VSS 0.39121f
C1953 a_177824_26040# VSS 0.41056f ; **FLOATING
C1954 a_176554_26040# VSS 0.04368f
C1955 a_176144_26040# VSS 0.04368f
C1956 a_174874_26040# VSS 0.39121f
C1957 a_174464_26040# VSS 0.4097f
C1958 a_173194_26040# VSS 0.39121f
C1959 a_172784_26040# VSS 0.41056f ; **FLOATING
C1960 a_171514_26040# VSS 0.38483f
C1961 a_171104_26040# VSS 0.38539f
C1962 a_169834_26040# VSS 0.04368f
C1963 a_169424_26040# VSS 0.04368f
C1964 a_168154_26040# VSS 0.04368f
C1965 a_167744_26040# VSS 0.04368f
C1966 a_166474_26040# VSS 0.39121f
C1967 a_166064_26040# VSS 0.41056f
C1968 a_164794_26040# VSS 0.38368f
C1969 a_164384_26040# VSS 0.38539f
C1970 a_163114_26040# VSS 0.39203f
C1971 a_162704_26040# VSS 0.4097f
C1972 a_161434_26040# VSS 0.39203f
C1973 a_161024_26040# VSS 0.41056f ; **FLOATING
C1974 a_159754_26040# VSS 0.04368f
C1975 a_159344_26040# VSS 0.04368f
C1976 a_158074_26040# VSS 0.39203f
C1977 a_157664_26040# VSS 0.4097f
C1978 a_156394_26040# VSS 0.39182f
C1979 a_155984_26040# VSS 0.4093f ; **FLOATING
C1980 a_154714_26040# VSS 0.38401f
C1981 a_154304_26040# VSS 0.386f
C1982 a_153034_26040# VSS 0.04368f
C1983 a_152624_26040# VSS 0.04368f
C1984 a_151354_26040# VSS 0.04368f
C1985 a_150944_26040# VSS 0.04368f
C1986 a_149674_26040# VSS 0.39121f
C1987 a_149264_26040# VSS 0.41138f ; **FLOATING
C1988 a_143514_26600# VSS 0.38721f ; **FLOATING
C1989 a_143104_26600# VSS 0.38367f
C1990 a_141760_26839# VSS 0.09961f
C1991 a_140864_26839# VSS 0.09961f
C1992 a_139520_26600# VSS 0.14509f
C1993 a_121100_21999# VSS 3.16589f ; **FLOATING
C1994 a_138624_26600# VSS 0.14509f
C1995 a_136932_26600# VSS 3.57578f
C1996 a_123480_21999# VSS 3.18183f ; **FLOATING
C1997 a_133241_26660# VSS 3.70508f ; **FLOATING
C1998 a_129500_21760# VSS 5.42155f ; **FLOATING
C1999 a_131280_26600# VSS 3.57578f
C2000 a_129608_26600# VSS 0.22758f
C2001 a_122881_26660# VSS 2.36655f ; **FLOATING
C2002 a_121869_26660# VSS 3.87871f ; **FLOATING
C2003 a_120920_26600# VSS 0.22758f
C2004 a_24094_26040# VSS 0.04368f
C2005 a_23684_26040# VSS 0.04368f
C2006 a_22414_26040# VSS 0.04368f
C2007 a_22004_26040# VSS 0.04368f
C2008 a_20734_26040# VSS 0.04368f
C2009 a_20324_26040# VSS 0.04368f
C2010 a_19054_26040# VSS 0.04368f
C2011 a_18644_26040# VSS 0.04368f
C2012 a_17374_26040# VSS 0.39374f
C2013 a_16964_26040# VSS 0.40738f
C2014 a_15694_26040# VSS 0.38401f ; **FLOATING
C2015 a_15400_26100# VSS 0.88266f ; **FLOATING
C2016 a_15284_26040# VSS 0.38545f
C2017 a_14014_26040# VSS 0.04368f
C2018 a_13604_26040# VSS 0.04368f
C2019 a_12334_26040# VSS 0.04368f
C2020 a_11924_26040# VSS 0.04368f
C2021 a_10654_26040# VSS 0.39313f
C2022 a_10244_26040# VSS 0.40738f ; **FLOATING
C2023 a_8974_26040# VSS 0.38401f
C2024 a_8680_26100# VSS 0.93065f ; **FLOATING
C2025 a_8564_26040# VSS 0.38545f
C2026 a_7294_26040# VSS 0.04368f
C2027 a_6884_26040# VSS 0.04368f
C2028 a_5614_26040# VSS 0.04368f
C2029 a_5204_26040# VSS 0.04368f
C2030 a_3934_26040# VSS 0.04368f
C2031 a_3524_26040# VSS 0.04368f
C2032 a_189994_30380# VSS 0.38721f
C2033 a_189584_30380# VSS 0.38371f
C2034 a_188314_30380# VSS 0.39521f ; **FLOATING
C2035 a_187904_30380# VSS 0.40732f ; **FLOATING
C2036 a_186634_30380# VSS 0.39439f
C2037 a_186224_30380# VSS 0.40732f
C2038 a_184954_30380# VSS 0.04368f
C2039 a_184544_30380# VSS 0.04368f
C2040 a_183274_30380# VSS 0.39313f
C2041 a_182864_30380# VSS 0.40738f
C2042 a_181594_30380# VSS 0.39313f
C2043 a_181184_30380# VSS 0.40732f
C2044 a_179914_30380# VSS 0.38401f
C2045 a_179504_30380# VSS 0.38539f
C2046 a_178234_30380# VSS 0.04368f
C2047 a_177824_30380# VSS 0.04368f
C2048 a_176554_30380# VSS 0.04368f
C2049 a_176144_30380# VSS 0.04368f
C2050 a_174874_30380# VSS 0.39121f
C2051 a_174464_30380# VSS 0.4093f ; **FLOATING
C2052 a_173194_30380# VSS 0.38371f ; **FLOATING
C2053 a_172784_30380# VSS 0.38545f
C2054 a_171514_30380# VSS 0.39121f
C2055 a_171104_30380# VSS 0.40875f
C2056 a_169834_30380# VSS 0.39121f
C2057 a_169424_30380# VSS 0.4093f ; **FLOATING
C2058 a_168154_30380# VSS 0.04368f
C2059 a_167744_30380# VSS 0.04368f
C2060 a_166474_30380# VSS 0.39313f ; **FLOATING
C2061 a_166064_30380# VSS 0.40732f ; **FLOATING
C2062 a_164794_30380# VSS 0.39121f
C2063 a_164384_30380# VSS 0.4093f ; **FLOATING
C2064 a_163114_30380# VSS 0.38401f
C2065 a_162704_30380# VSS 0.38541f
C2066 a_161434_30380# VSS 0.04368f
C2067 a_161024_30380# VSS 0.04368f
C2068 a_159754_30380# VSS 0.04368f
C2069 a_159344_30380# VSS 0.04368f
C2070 a_158074_30380# VSS 0.39121f
C2071 a_157664_30380# VSS 0.40738f ; **FLOATING
C2072 a_156394_30380# VSS 0.38453f ; **FLOATING
C2073 a_155984_30380# VSS 0.38545f
C2074 a_154714_30380# VSS 0.39203f
C2075 a_154304_30380# VSS 0.4097f
C2076 a_153034_30380# VSS 0.39203f
C2077 a_152624_30380# VSS 0.41056f ; **FLOATING
C2078 a_151354_30380# VSS 0.04368f
C2079 a_150944_30380# VSS 0.04368f
C2080 a_149674_30380# VSS 0.39121f ; **FLOATING
C2081 a_149264_30380# VSS 0.41138f ; **FLOATING
C2082 a_24094_30380# VSS 0.04368f
C2083 a_23684_30380# VSS 0.04368f
C2084 a_22414_30380# VSS 0.04368f
C2085 a_22004_30380# VSS 0.04368f
C2086 a_20734_30380# VSS 0.04368f
C2087 a_20324_30380# VSS 0.04368f
C2088 a_19054_30380# VSS 0.04368f
C2089 a_18644_30380# VSS 0.04368f
C2090 a_17374_30380# VSS 0.04368f
C2091 a_16964_30380# VSS 0.04368f
C2092 a_15694_30380# VSS 0.39313f
C2093 a_15284_30380# VSS 0.40799f ; **FLOATING
C2094 a_14014_30380# VSS 0.38432f
C2095 a_13720_30440# VSS 0.88557f ; **FLOATING
C2096 a_13604_30380# VSS 0.387f
C2097 a_12334_30380# VSS 0.04368f
C2098 a_11924_30380# VSS 0.04368f
C2099 a_10654_30380# VSS 0.04368f
C2100 a_10244_30380# VSS 0.04368f
C2101 a_8974_30380# VSS 0.04368f
C2102 a_8564_30380# VSS 0.04368f
C2103 a_7294_30380# VSS 0.04368f
C2104 a_6884_30380# VSS 0.04368f
C2105 a_5614_30380# VSS 0.04368f
C2106 a_5204_30380# VSS 0.04368f
C2107 a_3934_30380# VSS 0.39121f
C2108 a_3524_30380# VSS 0.40991f ; **FLOATING
C2109 a_190694_34720# VSS 0.39521f
C2110 a_190284_34720# VSS 0.40732f
C2111 a_189014_34720# VSS 0.38721f
C2112 a_188604_34720# VSS 0.38545f
C2113 a_187334_34720# VSS 0.04368f
C2114 a_186924_34720# VSS 0.04368f
C2115 a_185654_34720# VSS 0.04368f
C2116 a_185244_34720# VSS 0.04368f
C2117 a_183974_34720# VSS 0.39121f
C2118 a_183564_34720# VSS 0.41056f
C2119 a_182294_34720# VSS 0.38401f
C2120 a_181884_34720# VSS 0.38539f
C2121 a_180614_34720# VSS 0.39439f ; **FLOATING
C2122 a_180204_34720# VSS 0.40726f ; **FLOATING
C2123 a_178934_34720# VSS 0.39115f ; **FLOATING
C2124 a_178524_34720# VSS 0.4105f ; **FLOATING
C2125 a_177180_34720# VSS 0.07989f
C2126 a_176284_34720# VSS 0.07989f
C2127 a_175036_34720# VSS 0.57953f ; **FLOATING
C2128 a_174464_34720# VSS 0.58115f ; **FLOATING
C2129 a_173194_35062# VSS 0.23925f ; **FLOATING
C2130 a_172784_35062# VSS 0.23925f
C2131 a_171514_35062# VSS 0.23925f
C2132 a_171104_35062# VSS 0.23925f
C2133 a_169834_35062# VSS 0.24044f
C2134 a_169685_35122# VSS 5.14038f ; **FLOATING
C2135 a_169424_35062# VSS 0.25284f ; **FLOATING
C2136 a_168154_35062# VSS 0.24044f
C2137 a_167744_35062# VSS 0.25149f ; **FLOATING
C2138 a_166474_35062# VSS 0.24044f
C2139 a_166064_35062# VSS 0.25284f ; **FLOATING
C2140 a_164794_35062# VSS 0.23925f
C2141 a_164384_35062# VSS 0.23925f
C2142 a_163114_35062# VSS 0.23925f
C2143 a_162704_35062# VSS 0.23925f
C2144 a_161434_35062# VSS 0.24044f
C2145 a_161285_35122# VSS 3.15762f ; **FLOATING
C2146 a_161024_35062# VSS 0.25284f ; **FLOATING
C2147 a_159754_35062# VSS 0.23925f
C2148 a_159344_35062# VSS 0.23925f
C2149 a_158074_35062# VSS 0.23925f
C2150 a_157664_35062# VSS 0.23925f
C2151 a_156394_35062# VSS 0.24232f
C2152 a_151205_26100# VSS 3.80024f ; **FLOATING
C2153 a_155984_35062# VSS 0.25096f ; **FLOATING
C2154 a_154714_35062# VSS 0.23925f ; **FLOATING
C2155 a_154304_35062# VSS 0.23988f
C2156 a_153034_35062# VSS 0.23925f
C2157 a_152624_35062# VSS 0.23988f
C2158 a_151354_35062# VSS 0.24044f
C2159 a_151205_35122# VSS 9.80107f ; **FLOATING
C2160 a_150944_35062# VSS 0.2541f ; **FLOATING
C2161 a_149674_35062# VSS 0.23925f ; **FLOATING
C2162 a_149264_35062# VSS 0.24009f
C2163 a_140574_34580# VSS 0.04368f
C2164 a_140164_34580# VSS 0.04368f
C2165 a_138894_34922# VSS 0.24044f
C2166 a_138745_34982# VSS 5.0532f ; **FLOATING
C2167 a_138484_34922# VSS 0.2541f ; **FLOATING
C2168 a_132734_34580# VSS 0.04368f
C2169 a_132324_34580# VSS 0.04368f
C2170 a_131054_34922# VSS 0.24044f
C2171 a_121493_21789# VSS 10.0897f ; **FLOATING
C2172 a_130644_34922# VSS 0.25327f ; **FLOATING
C2173 a_24094_34720# VSS 0.38626f
C2174 a_3785_30440# VSS 4.89303f ; **FLOATING
C2175 a_23684_34720# VSS 0.38389f
C2176 a_22414_34720# VSS 0.04368f
C2177 a_22004_34720# VSS 0.04368f
C2178 a_20734_34720# VSS 0.04368f
C2179 a_20324_34720# VSS 0.04368f
C2180 a_19054_34720# VSS 0.39313f
C2181 a_18644_34720# VSS 0.40738f ; **FLOATING
C2182 a_17374_34720# VSS 0.38401f
C2183 a_17080_34780# VSS 0.8879f ; **FLOATING
C2184 a_16964_34720# VSS 0.38519f
C2185 a_15694_34720# VSS 0.04368f
C2186 a_15284_34720# VSS 0.04368f
C2187 a_14014_34720# VSS 0.04368f
C2188 a_13604_34720# VSS 0.04368f
C2189 a_12334_34720# VSS 0.04368f
C2190 a_11924_34720# VSS 0.04368f
C2191 a_10654_34720# VSS 0.04368f
C2192 a_10244_34720# VSS 0.04368f
C2193 a_8974_34720# VSS 0.04368f
C2194 a_8564_34720# VSS 0.04368f
C2195 a_7294_34720# VSS 0.04368f
C2196 a_6884_34720# VSS 0.04368f
C2197 a_5614_34720# VSS 0.04368f
C2198 a_5204_34720# VSS 0.04368f
C2199 a_3934_34720# VSS 0.04368f
C2200 a_3524_34720# VSS 0.04368f
C2201 a_189994_39542# VSS 0.24009f
C2202 a_189584_39542# VSS 0.23925f
C2203 a_188314_39542# VSS 0.24358f
C2204 a_159605_30440# VSS 8.73335f ; **FLOATING
C2205 a_187904_39542# VSS 0.25096f ; **FLOATING
C2206 a_186634_39542# VSS 0.24009f ; **FLOATING
C2207 a_186224_39542# VSS 0.24009f
C2208 a_184954_39542# VSS 0.24009f
C2209 a_184544_39542# VSS 0.23925f
C2210 a_183274_39542# VSS 0.24044f
C2211 a_183125_39602# VSS 2.16156f ; **FLOATING
C2212 a_182864_39542# VSS 0.2541f ; **FLOATING
C2213 a_181594_39200# VSS 0.07326f
C2214 a_152885_21760# VSS 15.1107f ; **FLOATING
C2215 a_181184_39200# VSS 0.07326f
C2216 a_179914_39200# VSS 0.07326f
C2217 a_179504_39200# VSS 0.07326f
C2218 a_178234_39200# VSS 0.07326f
C2219 a_177824_39200# VSS 0.07326f
C2220 a_176554_39200# VSS 0.07326f
C2221 a_151060_21760# VSS 12.0365f ; **FLOATING
C2222 a_176144_39200# VSS 0.07326f
C2223 a_174874_39200# VSS 0.07326f
C2224 a_169567_35509# VSS 8.62881f ; **FLOATING
C2225 a_174464_39200# VSS 0.07326f
C2226 a_173194_39200# VSS 0.07326f
C2227 a_171220_35122# VSS 10.5583f ; **FLOATING
C2228 a_172784_39200# VSS 0.07326f
C2229 a_171514_39200# VSS 0.07326f
C2230 a_151087_22349# VSS 15.8468f ; **FLOATING
C2231 a_171104_39200# VSS 0.07326f
C2232 a_169834_39200# VSS 0.07326f
C2233 a_169685_39260# VSS 10.895f ; **FLOATING
C2234 a_169424_39200# VSS 0.07326f
C2235 a_168154_39200# VSS 0.07326f
C2236 a_167744_39200# VSS 0.07326f
C2237 a_166474_39200# VSS 0.07326f
C2238 a_166325_39260# VSS 0.39441f ; **FLOATING
C2239 a_166064_39200# VSS 0.07326f
C2240 a_164794_39200# VSS 0.07326f
C2241 a_164645_35122# VSS 6.53642f ; **FLOATING
C2242 a_164384_39200# VSS 0.07326f
C2243 a_163114_39200# VSS 0.07326f
C2244 a_162965_39260# VSS 8.30488f ; **FLOATING
C2245 a_162704_39200# VSS 0.07326f
C2246 a_161434_39200# VSS 0.07326f
C2247 a_161140_39260# VSS 3.79366f ; **FLOATING
C2248 a_161024_39200# VSS 0.07326f
C2249 a_159754_39200# VSS 0.07326f
C2250 a_159605_39260# VSS 9.1808f ; **FLOATING
C2251 a_159344_39200# VSS 0.07326f
C2252 a_158074_39200# VSS 0.07326f
C2253 a_157780_39260# VSS 4.72321f ; **FLOATING
C2254 a_157664_39200# VSS 0.07326f
C2255 a_156394_39200# VSS 0.07326f
C2256 a_156245_39260# VSS 6.36137f ; **FLOATING
C2257 a_155984_39200# VSS 0.07326f
C2258 a_154714_39200# VSS 0.07326f
C2259 a_154565_39260# VSS 8.76572f ; **FLOATING
C2260 a_154304_39200# VSS 0.07326f
C2261 a_153034_39200# VSS 0.07326f
C2262 a_152885_39260# VSS 6.18979f ; **FLOATING
C2263 a_152624_39200# VSS 0.07326f
C2264 a_151354_39200# VSS 0.07326f
C2265 a_151205_39260# VSS 11.3711f ; **FLOATING
C2266 a_150944_39200# VSS 0.07326f
C2267 a_149674_39200# VSS 0.07326f
C2268 a_149380_39260# VSS 7.26873f ; **FLOATING
C2269 a_149264_39200# VSS 0.07326f
C2270 a_24094_39060# VSS 0.39521f
C2271 a_23684_39060# VSS 0.4082f ; **FLOATING
C2272 a_22414_39060# VSS 0.38483f
C2273 a_22120_39120# VSS 1.12453f ; **FLOATING
C2274 a_22004_39060# VSS 0.38539f
C2275 a_20734_39402# VSS 0.24128f ; **FLOATING
C2276 a_20324_39402# VSS 0.2541f ; **FLOATING
C2277 a_19054_39402# VSS 0.24044f ; **FLOATING
C2278 a_18644_39402# VSS 0.2541f ; **FLOATING
C2279 a_17374_39402# VSS 0.24358f ; **FLOATING
C2280 a_16964_39402# VSS 0.25327f ; **FLOATING
C2281 a_15694_39402# VSS 0.24128f
C2282 a_15545_21760# VSS 7.69765f ; **FLOATING
C2283 a_15284_39402# VSS 0.25327f ; **FLOATING
C2284 a_14014_39402# VSS 0.24128f
C2285 a_13865_21760# VSS 8.22352f ; **FLOATING
C2286 a_13604_39402# VSS 0.25327f ; **FLOATING
C2287 a_12334_39402# VSS 0.24128f
C2288 a_12185_21760# VSS 8.07062f ; **FLOATING
C2289 a_11924_39402# VSS 0.25327f ; **FLOATING
C2290 a_5465_21760# VSS 7.94157f ; **FLOATING
C2291 a_10654_39060# VSS 0.53581f
C2292 a_10244_39060# VSS 0.55653f
C2293 a_8974_39060# VSS 0.52235f
C2294 a_8680_39120# VSS 1.18966f ; **FLOATING
C2295 a_8564_39060# VSS 0.52159f
C2296 a_7294_39060# VSS 0.52095f
C2297 a_3785_21760# VSS 9.86235f ; **FLOATING
C2298 a_7000_39120# VSS 0.82768f ; **FLOATING
C2299 a_6884_39060# VSS 0.52189f
C2300 a_5614_39060# VSS 0.53441f
C2301 a_5204_39060# VSS 0.55653f
C2302 a_5347_39849# VSS 9.4977f ; **FLOATING
C2303 a_3934_39060# VSS 0.52095f
C2304 a_3640_39120# VSS 1.02614f ; **FLOATING
C2305 a_3524_39060# VSS 0.52329f
C2306 a_189994_43820# VSS 0.07326f
C2307 a_149525_26100# VSS 11.9621f ; **FLOATING
C2308 a_189584_43820# VSS 0.07326f
C2309 a_188314_43820# VSS 0.07326f
C2310 a_166325_35122# VSS 7.86665f ; **FLOATING
C2311 a_149407_26689# VSS 14.7341f ; **FLOATING
C2312 a_187904_43820# VSS 0.07326f
C2313 a_186634_43820# VSS 0.07326f
C2314 a_186224_43820# VSS 0.07326f
C2315 a_184954_43820# VSS 0.07326f
C2316 a_149407_40129# VSS 16.7697f ; **FLOATING
C2317 a_184544_43820# VSS 0.07326f
C2318 a_183274_43820# VSS 0.07326f
C2319 a_182864_43820# VSS 0.07326f
C2320 a_181594_43820# VSS 0.07326f
C2321 a_154447_40129# VSS 17.5723f ; **FLOATING
C2322 a_181184_43820# VSS 0.07326f
C2323 a_179914_43820# VSS 0.07326f
C2324 a_154420_35122# VSS 15.5896f ; **FLOATING
C2325 a_179504_43820# VSS 0.07326f
C2326 a_178234_43820# VSS 0.07326f
C2327 a_151087_35509# VSS 14.8963f ; **FLOATING
C2328 a_177824_43820# VSS 0.07326f
C2329 a_176554_43820# VSS 0.07326f
C2330 a_152740_35122# VSS 10.7339f ; **FLOATING
C2331 a_176144_43820# VSS 0.07326f
C2332 a_174874_43820# VSS 0.07326f
C2333 a_152767_35509# VSS 9.50816f ; **FLOATING
C2334 a_174464_43820# VSS 0.07326f
C2335 a_173194_43820# VSS 0.07326f
C2336 a_154447_35509# VSS 13.2628f ; **FLOATING
C2337 a_172784_43820# VSS 0.07326f
C2338 a_171514_43820# VSS 0.07326f
C2339 a_171104_43820# VSS 0.07326f
C2340 a_169834_43820# VSS 0.07326f
C2341 a_164645_30440# VSS 7.89583f ; **FLOATING
C2342 a_169424_43820# VSS 0.07326f
C2343 a_168154_43820# VSS 0.07326f
C2344 a_149380_35122# VSS 8.92021f ; **FLOATING
C2345 a_167744_43820# VSS 0.07326f
C2346 a_166474_43820# VSS 0.07326f
C2347 a_157925_30440# VSS 6.39495f ; **FLOATING
C2348 a_166064_43820# VSS 0.07326f
C2349 a_164794_43820# VSS 0.07326f
C2350 a_156100_30440# VSS 7.39616f ; **FLOATING
C2351 a_164384_43820# VSS 0.07326f
C2352 a_163114_43820# VSS 0.07326f
C2353 a_154565_30440# VSS 8.7331f ; **FLOATING
C2354 a_162704_43820# VSS 0.07326f
C2355 a_161434_43820# VSS 0.07326f
C2356 a_149407_35509# VSS 12.5204f ; **FLOATING
C2357 a_161024_43820# VSS 0.07326f
C2358 a_159754_43820# VSS 0.07326f
C2359 a_159344_43820# VSS 0.07326f
C2360 a_158074_43820# VSS 0.07326f
C2361 a_149407_31029# VSS 8.62544f ; **FLOATING
C2362 a_157664_43820# VSS 0.07326f
C2363 a_156394_43820# VSS 0.07326f
C2364 a_151060_30440# VSS 8.49928f ; **FLOATING
C2365 a_155984_43820# VSS 0.07326f
C2366 a_154714_43820# VSS 0.07326f
C2367 a_154565_43880# VSS 8.13801f ; **FLOATING
C2368 a_154304_43820# VSS 0.07326f
C2369 a_153034_43820# VSS 0.07326f
C2370 a_152740_43880# VSS 6.07177f ; **FLOATING
C2371 a_152624_43820# VSS 0.07326f
C2372 a_151354_43820# VSS 0.07326f
C2373 a_150944_43820# VSS 0.07326f
C2374 a_149674_43820# VSS 0.07326f
C2375 a_149264_43820# VSS 0.07326f
C2376 a_24094_43540# VSS 0.52329f
C2377 a_3785_26100# VSS 15.2603f ; **FLOATING
C2378 a_3785_39120# VSS 5.13893f ; **FLOATING
C2379 a_23684_43540# VSS 0.52095f
C2380 a_22414_43540# VSS 0.53581f
C2381 a_22004_43540# VSS 0.55513f
C2382 a_20734_43540# VSS 0.52235f
C2383 a_20440_43600# VSS 1.2045f ; **FLOATING
C2384 a_20324_43540# VSS 0.52159f
C2385 a_19054_43540# VSS 0.52095f
C2386 a_3667_26689# VSS 11.6135f ; **FLOATING
C2387 a_18760_43600# VSS 0.8503f ; **FLOATING
C2388 a_18644_43540# VSS 0.52189f
C2389 a_13865_30440# VSS 7.19708f ; **FLOATING
C2390 a_17374_43540# VSS 0.534f
C2391 a_16964_43540# VSS 0.55513f
C2392 a_15694_43540# VSS 0.52095f
C2393 a_15400_43600# VSS 1.04214f ; **FLOATING
C2394 a_15284_43540# VSS 0.52159f
C2395 a_14014_43540# VSS 0.52095f
C2396 a_3667_31029# VSS 8.14831f ; **FLOATING
C2397 a_13720_43600# VSS 0.77308f ; **FLOATING
C2398 a_13604_43540# VSS 0.52329f
C2399 a_5347_22349# VSS 21.8338f ; **FLOATING
C2400 a_12334_43540# VSS 0.53581f
C2401 a_11924_43540# VSS 0.55653f
C2402 a_3667_35369# VSS 9.13449f ; **FLOATING
C2403 a_10654_43540# VSS 0.52235f
C2404 a_10360_43600# VSS 1.22936f ; **FLOATING
C2405 a_10244_43540# VSS 0.52159f
C2406 a_8974_43540# VSS 0.52095f
C2407 a_8825_43600# VSS 7.34091f ; **FLOATING
C2408 a_8680_43600# VSS 0.75422f ; **FLOATING
C2409 a_8564_43540# VSS 0.52189f
C2410 a_7294_43540# VSS 0.534f
C2411 a_6884_43540# VSS 0.55513f
C2412 a_5614_43540# VSS 0.52095f
C2413 a_5320_43600# VSS 1.05903f ; **FLOATING
C2414 a_5204_43540# VSS 0.52299f
C2415 a_5347_44329# VSS 30.1531f ; **FLOATING
C2416 a_3934_43540# VSS 0.52095f
C2417 a_3785_43600# VSS 10.6198f ; **FLOATING
C2418 a_3640_43600# VSS 0.93657f ; **FLOATING
C2419 a_3524_43540# VSS 0.52329f
C2420 a_3667_44329# VSS 9.5341f ; **FLOATING
C2421 a_3667_22349.t4 VSS 0.34018f ; **FLOATING
C2422 a_3667_22349.t6 VSS 0.17407f ; **FLOATING
C2423 a_3667_22349.n0 VSS 2.31259f ; **FLOATING
C2424 a_3667_22349.t7 VSS 0.17407f ; **FLOATING
C2425 a_3667_22349.n1 VSS 0.93277f ; **FLOATING
C2426 a_3667_22349.t10 VSS 0.34193f ; **FLOATING
C2427 a_3667_22349.t11 VSS 0.17189f ; **FLOATING
C2428 a_3667_22349.n2 VSS 2.20209f ; **FLOATING
C2429 a_3667_22349.t0 VSS 0.13667f ; **FLOATING
C2430 a_3667_22349.n3 VSS 1.47241f ; **FLOATING
C2431 a_3667_22349.n4 VSS 1.14043f ; **FLOATING
C2432 a_3667_22349.t12 VSS 0.40347f ; **FLOATING
C2433 a_3667_22349.t9 VSS 0.17189f ; **FLOATING
C2434 a_3667_22349.n5 VSS 3.08556f ; **FLOATING
C2435 a_3667_22349.t8 VSS 0.17582f ; **FLOATING
C2436 a_3667_22349.n6 VSS 0.96707f ; **FLOATING
C2437 a_3667_22349.n7 VSS 1.1257f ; **FLOATING
C2438 a_3667_22349.t5 VSS 1.88492f ; **FLOATING
C2439 a_3667_22349.t2 VSS 4.57677f ; **FLOATING
C2440 a_3667_22349.t3 VSS 2.09936f ; **FLOATING
C2441 a_3667_22349.t1 VSS 0.96981f ; **FLOATING
C2442 a_5465_3840.t2 VSS 0.3755f ; **FLOATING
C2443 a_5465_3840.t3 VSS 0.12696f ; **FLOATING
C2444 a_5465_3840.n0 VSS 6.10224f ; **FLOATING
C2445 a_5465_3840.t0 VSS 4.51013f ; **FLOATING
C2446 a_5465_3840.t1 VSS 0.2621f ; **FLOATING
C2447 a_149525_43880.t2 VSS 0.2146f ; **FLOATING
C2448 a_149525_43880.t5 VSS 0.3728f ; **FLOATING
C2449 a_149525_43880.n0 VSS 2.71769f ; **FLOATING
C2450 a_149525_43880.t3 VSS 0.21115f ; **FLOATING
C2451 a_149525_43880.n1 VSS 1.3773f ; **FLOATING
C2452 a_149525_43880.t4 VSS 0.19752f ; **FLOATING
C2453 a_149525_43880.t0 VSS 0.44818f ; **FLOATING
C2454 a_149525_43880.n2 VSS 0.81107f ; **FLOATING
C2455 a_149525_43880.n3 VSS 5.70091f ; **FLOATING
C2456 a_149525_43880.t6 VSS 6.28837f ; **FLOATING
C2457 a_149525_43880.t7 VSS 2.46751f ; **FLOATING
C2458 a_149525_43880.t1 VSS 0.85136f ; **FLOATING
C2459 a_151087_31029.t3 VSS 0.31638f ; **FLOATING
C2460 a_151087_31029.t4 VSS 0.43582f ; **FLOATING
C2461 a_151087_31029.n0 VSS 4.11981f ; **FLOATING
C2462 a_151087_31029.t1 VSS 6.2263f ; **FLOATING
C2463 a_151087_31029.t2 VSS 7.60642f ; **FLOATING
C2464 a_151087_31029.t5 VSS 2.67907f ; **FLOATING
C2465 a_151087_31029.t0 VSS 0.72826f ; **FLOATING
C2466 a_149525_30440.t0 VSS 0.93655f ; **FLOATING
C2467 a_149525_30440.t1 VSS 0.34086f ; **FLOATING
C2468 a_149525_30440.n0 VSS 6.47043f ; **FLOATING
C2469 a_149525_30440.t2 VSS 7.82569f ; **FLOATING
C2470 a_149525_30440.t4 VSS 3.45547f ; **FLOATING
C2471 a_149525_30440.t3 VSS 1.08122f ; **FLOATING
C2472 a_149525_35122.t1 VSS 1.763f ; **FLOATING
C2473 a_149525_35122.t0 VSS 3.73469f ; **FLOATING
C2474 a_149525_35122.t2 VSS 6.37573f ; **FLOATING
C2475 a_149525_35122.t4 VSS 4.47544f ; **FLOATING
C2476 a_149525_35122.t3 VSS 1.78778f ; **FLOATING
C2477 a_154565_35122.t4 VSS 2.64041f ; **FLOATING
C2478 a_154565_35122.t5 VSS 4.864f ; **FLOATING
C2479 a_154565_35122.t2 VSS 1.88107f ; **FLOATING
C2480 a_154565_35122.t0 VSS 2.29501f ; **FLOATING
C2481 a_154565_35122.t3 VSS 3.73522f ; **FLOATING
C2482 a_154565_35122.t1 VSS 1.17008f ; **FLOATING
C2483 a_154447_26689.t4 VSS 0.20094f ; **FLOATING
C2484 a_154447_26689.t2 VSS 0.17635f ; **FLOATING
C2485 a_154447_26689.t3 VSS 0.22146f ; **FLOATING
C2486 a_154447_26689.n0 VSS 1.89433f ; **FLOATING
C2487 a_154447_26689.n1 VSS 5.37799f ; **FLOATING
C2488 a_154447_26689.t0 VSS 5.93772f ; **FLOATING
C2489 a_154447_26689.t5 VSS 2.83326f ; **FLOATING
C2490 a_154447_26689.t1 VSS 0.69511f ; **FLOATING
C2491 a_7027_22349.t1 VSS 2.45275f ; **FLOATING
C2492 a_7027_22349.t4 VSS 0.23064f ; **FLOATING
C2493 a_7027_22349.t2 VSS 0.08324f ; **FLOATING
C2494 a_7027_22349.n0 VSS 6.69095f ; **FLOATING
C2495 a_7027_22349.t5 VSS 7.54454f ; **FLOATING
C2496 a_7027_22349.t3 VSS 0.87204f ; **FLOATING
C2497 a_7027_22349.t0 VSS 0.10017f ; **FLOATING
C2498 a_18905_21760.t2 VSS 0.05772f ; **FLOATING
C2499 a_18905_21760.t3 VSS 0.05772f ; **FLOATING
C2500 a_18905_21760.n0 VSS 0.08313f ; **FLOATING
C2501 a_18905_21760.t6 VSS 0.0618f ; **FLOATING
C2502 a_18905_21760.t7 VSS 0.03292f ; **FLOATING
C2503 a_18905_21760.n1 VSS 0.60392f ; **FLOATING
C2504 a_18905_21760.t4 VSS 0.05772f ; **FLOATING
C2505 a_18905_21760.t5 VSS 0.05772f ; **FLOATING
C2506 a_18905_21760.n2 VSS 0.52941f ; **FLOATING
C2507 a_18905_21760.n3 VSS 1.96355f ; **FLOATING
C2508 a_18905_21760.n4 VSS 4.62473f ; **FLOATING
C2509 a_18905_21760.t0 VSS 6.3714f ; **FLOATING
C2510 a_18905_21760.t1 VSS 0.40001f ; **FLOATING
C2511 a_20585_21760.t2 VSS 0.07145f ; **FLOATING
C2512 a_20585_21760.t3 VSS 0.03443f ; **FLOATING
C2513 a_20585_21760.n0 VSS 4.58054f ; **FLOATING
C2514 a_20585_21760.t1 VSS 5.02525f ; **FLOATING
C2515 a_20585_21760.t0 VSS 0.47874f ; **FLOATING
C2516 a_149525_21760.t2 VSS 0.24462f ; **FLOATING
C2517 a_149525_21760.t0 VSS 0.33424f ; **FLOATING
C2518 a_149525_21760.n0 VSS 4.0645f ; **FLOATING
C2519 a_149525_21760.t5 VSS 9.07432f ; **FLOATING
C2520 a_149525_21760.t4 VSS 2.93532f ; **FLOATING
C2521 a_149525_21760.t3 VSS 3.24599f ; **FLOATING
C2522 a_149525_21760.t1 VSS 1.61089f ; **FLOATING
C2523 a_34200_24066.t0 VSS 0.0171f ; **FLOATING
C2524 a_34200_24066.t2 VSS 0.01317f ; **FLOATING
C2525 a_34200_24066.n0 VSS 1.08969f ; **FLOATING
C2526 a_34200_24066.t5 VSS 21.5991f ; **FLOATING
C2527 a_34200_24066.n1 VSS 4.5949f ; **FLOATING
C2528 a_34200_24066.t4 VSS 1.78892f ; **FLOATING
C2529 a_34200_24066.t1 VSS 0.27546f ; **FLOATING
C2530 a_121569_21999.t3 VSS 0.07102f ; **FLOATING
C2531 a_121569_21999.t4 VSS 18.1328f ; **FLOATING
C2532 a_121569_21999.t0 VSS 0.82068f ; **FLOATING
C2533 FB.t6 VSS 0.10647f ; **FLOATING
C2534 FB.t4 VSS 0.11036f ; **FLOATING
C2535 FB.t5 VSS 0.09304f ; **FLOATING
C2536 FB.t7 VSS 0.35465f ; **FLOATING
C2537 FB.n0 VSS 2.82901f ; **FLOATING
C2538 FB.n1 VSS 1.76395f ; **FLOATING
C2539 FB.n2 VSS 11.9186f ; **FLOATING
C2540 FB.t3 VSS 0.10988f ; **FLOATING
C2541 FB.t2 VSS 0.07755f ; **FLOATING
C2542 FB.n3 VSS 3.05981f ; **FLOATING
C2543 FB.t0 VSS 0.13395f ; **FLOATING
C2544 FB.n4 VSS 3.25721f ; **FLOATING
C2545 FB.t1 VSS 3.7417f ; **FLOATING
C2546 FB.n5 VSS 12.4719f ; **FLOATING
C2547 ICP2.t0 VSS 0.03702f ; **FLOATING
C2548 ICP2.t1 VSS 0.03702f ; **FLOATING
C2549 ICP2.n0 VSS 0.47444f ; **FLOATING
C2550 ICP2.t2 VSS 0.06041f ; **FLOATING
C2551 ICP2.t3 VSS 0.03218f ; **FLOATING
C2552 ICP2.n1 VSS 0.40071f ; **FLOATING
C2553 ICP2.n2 VSS 6.81839f ; **FLOATING
C2554 PB.t7 VSS 1.06409f ; **FLOATING
C2555 PB.t6 VSS 1.06409f ; **FLOATING
C2556 PB.t5 VSS 1.06409f ; **FLOATING
C2557 PB.t4 VSS 1.06409f ; **FLOATING
C2558 PB.t3 VSS 1.06409f ; **FLOATING
C2559 PB.t2 VSS 1.06409f ; **FLOATING
C2560 PB.t1 VSS 1.06409f ; **FLOATING
C2561 PB.t0 VSS 1.38032f ; **FLOATING
C2562 PB.n0 VSS 0.75432f ; **FLOATING
C2563 PB.n1 VSS 0.53883f ; **FLOATING
C2564 PB.n2 VSS 0.53883f ; **FLOATING
C2565 PB.n3 VSS 0.53883f ; **FLOATING
C2566 PB.n4 VSS 0.53883f ; **FLOATING
C2567 PB.n5 VSS 0.53883f ; **FLOATING
C2568 PB.n6 VSS 0.50066f ; **FLOATING
C2569 PB.t8 VSS 1.06409f ; **FLOATING
C2570 PB.t9 VSS 1.06409f ; **FLOATING
C2571 PB.t10 VSS 1.06409f ; **FLOATING
C2572 PB.t11 VSS 1.06409f ; **FLOATING
C2573 PB.t12 VSS 1.06409f ; **FLOATING
C2574 PB.t13 VSS 1.06409f ; **FLOATING
C2575 PB.t14 VSS 1.06409f ; **FLOATING
C2576 PB.t15 VSS 1.38032f ; **FLOATING
C2577 PB.n7 VSS 0.75432f ; **FLOATING
C2578 PB.n8 VSS 0.53883f ; **FLOATING
C2579 PB.n9 VSS 0.53883f ; **FLOATING
C2580 PB.n10 VSS 0.53883f ; **FLOATING
C2581 PB.n11 VSS 0.53883f ; **FLOATING
C2582 PB.n12 VSS 0.53883f ; **FLOATING
C2583 PB.n13 VSS 0.50066f ; **FLOATING
C2584 PB.n14 VSS 10.3458f ; **FLOATING
C2585 NB.t4 VSS 0.4316f ; **FLOATING
C2586 NB.t3 VSS 0.4316f ; **FLOATING
C2587 NB.t2 VSS 0.4316f ; **FLOATING
C2588 NB.t1 VSS 0.4316f ; **FLOATING
C2589 NB.t0 VSS 0.55986f ; **FLOATING
C2590 NB.n0 VSS 0.30595f ; **FLOATING
C2591 NB.n1 VSS 0.21855f ; **FLOATING
C2592 NB.n2 VSS 0.21855f ; **FLOATING
C2593 NB.n3 VSS 0.20307f ; **FLOATING
C2594 NB.t5 VSS 0.4316f ; **FLOATING
C2595 NB.t6 VSS 0.4316f ; **FLOATING
C2596 NB.t7 VSS 0.4316f ; **FLOATING
C2597 NB.t8 VSS 0.4316f ; **FLOATING
C2598 NB.t9 VSS 0.55986f ; **FLOATING
C2599 NB.n4 VSS 0.30595f ; **FLOATING
C2600 NB.n5 VSS 0.21855f ; **FLOATING
C2601 NB.n6 VSS 0.21855f ; **FLOATING
C2602 NB.n7 VSS 0.20307f ; **FLOATING
C2603 NB.n8 VSS 4.30481f ; **FLOATING
C2604 VCTRL.t1 VSS 10.7355f ; **FLOATING
C2605 VCTRL.t0 VSS 0.07242f ; **FLOATING
C2606 VCTRL.n0 VSS 2.11725f ; **FLOATING
.ends
