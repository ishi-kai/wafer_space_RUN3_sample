.subckt bias_if NB PBV VDD VSS
XMTR PBV NB VSS VSS nfet_03v3 L=2u W=16u nf=2  m=1
XMPR PBV PBV VDD VDD pfet_03v3 L=0.56u W=12u nf=2  m=1
XCPBV PBV VDD cap_mim_2f0_m4m5_noshield c_width=40e-6 c_length=40e-6 m=1
.ends
.subckt gmc_lpf1 INP INN VTN OUTP OUTN VDD VSS
XG1 INP INN xp xn VTN VDD VSS gm_unit
XG2 OUTN OUTP xp xn VTN VDD VSS gm_unit
XC1A xp xn cap_mim_2f0_m4m5_noshield c_width=30.82e-6 c_length=30.82e-6 m=1
XC1B xn xp cap_mim_2f0_m4m5_noshield c_width=30.82e-6 c_length=30.82e-6 m=1
XG3 xp xn OUTP OUTN VTN VDD VSS gm_unit
XG4 OUTN OUTP OUTP OUTN VTN VDD VSS gm_unit
XC2A OUTP OUTN cap_mim_2f0_m4m5_noshield c_width=16.58e-6 c_length=16.58e-6 m=1
XC2B OUTN OUTP cap_mim_2f0_m4m5_noshield c_width=16.58e-6 c_length=16.58e-6 m=1
.ends
.subckt gm_unit INP INN OUTP OUTN VTN VDD VSS
XMT t VTN VSS VSS nfet_03v3 L=2u W=32u nf=4  m=2
XM1 OUTN INP t VSS nfet_03v3 L=1u W=6u nf=2  m=1
XM2 OUTP INN t VSS nfet_03v3 L=1u W=6u nf=2  m=1
XMP1A OUTN OUTN VDD VDD pfet_03v3 L=2u W=16u nf=4  m=1
XMP1B OUTN OUTP VDD VDD pfet_03v3 L=2u W=16u nf=4  m=1
XMP2A OUTP OUTP VDD VDD pfet_03v3 L=2u W=16u nf=4  m=1
XMP2B OUTP OUTN VDD VDD pfet_03v3 L=2u W=16u nf=4  m=1
.ends
.subckt gmc_lpf2 INP INN VTN OUTP OUTN VDD VSS
XG1 INP INN xp xn VTN VDD VSS gm_unit
XG2 OUTN OUTP xp xn VTN VDD VSS gm_unit
XC1A xp xn cap_mim_2f0_m4m5_noshield c_width=20e-6 c_length=20e-6 m=1
XC1B xn xp cap_mim_2f0_m4m5_noshield c_width=20e-6 c_length=20e-6 m=1
XG3 xp xn OUTP OUTN VTN VDD VSS gm_unit
XG4 OUTN OUTP OUTP OUTN VTN VDD VSS gm_unit
XC2A OUTP OUTN cap_mim_2f0_m4m5_noshield c_width=25.98e-6 c_length=25.98e-6 m=1
XC2B OUTN OUTP cap_mim_2f0_m4m5_noshield c_width=25.98e-6 c_length=25.98e-6 m=1
.ends
.subckt vga INP INN GA GB NB PBV OUTP OUTN VDD VSS
XCC1 gp INP cap_mim_2f0_m4m5_noshield c_width=52.2e-6 c_length=52.2e-6 m=1
XCC2 gn INN cap_mim_2f0_m4m5_noshield c_width=52.2e-6 c_length=52.2e-6 m=1
XRB1 PBV gp VSS ppolyf_u_1k r_width=1u r_length=100u
XRB2 PBV gn VSS ppolyf_u_1k r_width=1u r_length=100u
XMT t NB VSS VSS nfet_03v3 L=2u W=32u nf=4  m=8
XM1 OUTN gp t VSS nfet_03v3 L=0.28u W=40u nf=8  m=1
XM2 OUTP gn t VSS nfet_03v3 L=0.28u W=40u nf=8  m=1
XMP0N OUTN OUTN VDD VDD pfet_03v3 L=0.56u W=24u nf=4  m=1
XMP0P OUTP OUTP VDD VDD pfet_03v3 L=0.56u W=24u nf=4  m=1
XMGAN gab GA VSS VSS nfet_03v3 L=1u W=4u nf=1  m=1
XMGAP gab GA VDD VDD pfet_03v3 L=1u W=4u nf=1  m=1
XTGAN1 gan gab OUTN VSS nfet_03v3 L=0.28u W=2u nf=1  m=1
XTGAP1 gan GA OUTN VDD pfet_03v3 L=0.28u W=4u nf=1  m=1
XTGAN2 gan GA PBV VSS nfet_03v3 L=0.28u W=2u nf=1  m=1
XTGAP2 gan gab PBV VDD pfet_03v3 L=0.28u W=4u nf=1  m=1
XTGBN1 gap gab OUTP VSS nfet_03v3 L=0.28u W=2u nf=1  m=1
XTGBP1 gap GA OUTP VDD pfet_03v3 L=0.28u W=4u nf=1  m=1
XTGBN2 gap GA PBV VSS nfet_03v3 L=0.28u W=2u nf=1  m=1
XTGBP2 gap gab PBV VDD pfet_03v3 L=0.28u W=4u nf=1  m=1
XMPAN OUTN gan VDD VDD pfet_03v3 L=0.56u W=24u nf=4  m=1
XMPAP OUTP gap VDD VDD pfet_03v3 L=0.56u W=24u nf=4  m=1
XMGBN gbb GB VSS VSS nfet_03v3 L=1u W=4u nf=1  m=1
XMGBP gbb GB VDD VDD pfet_03v3 L=1u W=4u nf=1  m=1
XTGCN1 gbn gbb OUTN VSS nfet_03v3 L=0.28u W=2u nf=1  m=1
XTGCP1 gbn GB OUTN VDD pfet_03v3 L=0.28u W=4u nf=1  m=1
XTGCN2 gbn GB PBV VSS nfet_03v3 L=0.28u W=2u nf=1  m=1
XTGCP2 gbn gbb PBV VDD pfet_03v3 L=0.28u W=4u nf=1  m=1
XTGDN1 gbp gbb OUTP VSS nfet_03v3 L=0.28u W=2u nf=1  m=1
XTGDP1 gbp GB OUTP VDD pfet_03v3 L=0.28u W=4u nf=1  m=1
XTGDN2 gbp GB PBV VSS nfet_03v3 L=0.28u W=2u nf=1  m=1
XTGDP2 gbp gbb PBV VDD pfet_03v3 L=0.28u W=4u nf=1  m=1
XMPBN OUTN gbn VDD VDD pfet_03v3 L=0.56u W=48u nf=8  m=1
XMPBP OUTP gbp VDD VDD pfet_03v3 L=0.56u W=48u nf=8  m=1
.ends
.subckt vga_fix INP INN NB PBV OUTP OUTN VDD VSS
XCC1 gp INP cap_mim_2f0_m4m5_noshield c_width=52.2e-6 c_length=52.2e-6 m=1
XCC2 gn INN cap_mim_2f0_m4m5_noshield c_width=52.2e-6 c_length=52.2e-6 m=1
XRB1 PBV gp VSS ppolyf_u_1k r_width=1u r_length=100u
XRB2 PBV gn VSS ppolyf_u_1k r_width=1u r_length=100u
XMT t NB VSS VSS nfet_03v3 L=2u W=32u nf=4  m=8
XM1 OUTN gp t VSS nfet_03v3 L=0.28u W=40u nf=8  m=1
XM2 OUTP gn t VSS nfet_03v3 L=0.28u W=40u nf=8  m=1
XMPDN OUTN OUTN VDD VDD pfet_03v3 L=0.56u W=24u nf=4  m=1
XMPDP OUTP OUTP VDD VDD pfet_03v3 L=0.56u W=24u nf=4  m=1
XMPCN OUTN PBV VDD VDD pfet_03v3 L=0.56u W=72u nf=12  m=1
XMPCP OUTP PBV VDD VDD pfet_03v3 L=0.56u W=72u nf=12  m=1
.ends
.subckt if_chain INP INN G1A G1B G2A G2B G3A G3B NB VTN OUTP OUTN VDD VSS
XBIF NB pbv VDD VSS bias_if
XV1 INP INN G1A G1B NB pbv a1p a1n VDD VSS vga
XF1 a1p a1n VTN f1p f1n VDD VSS gmc_lpf1
XV2 f1p f1n G2A G2B NB pbv a2p a2n VDD VSS vga
XF2 a2p a2n VTN f2p f2n VDD VSS gmc_lpf2
XV3 f2p f2n G3A G3B NB pbv a3p a3n VDD VSS vga
XV4 a3p a3n NB pbv a4p a4n VDD VSS vga_fix
XV5 a4p a4n NB pbv OUTP OUTN VDD VSS vga_fix
.ends
