* NGSPICE file created from gm_master_flat.ext - technology: gf180mcuD

.subckt gm_master_flat VSS VDD REFCK NB PB BWK BWN VTN
X0 a_1749_20389.t0 a_3181_19520# VDD VDD pfet_03v3 ad=1.06p pd=4.53u as=1.06p ps=4.53u w=4u l=2u
X1 a_6720_24379# a_1749_20389.t9 VTN.t0 VDD pfet_03v3 ad=3.56p pd=16.89u as=2.12p ps=8.53u w=8u l=2u
X2 a_1545_10280.t1 a_1427_2049# a_1400_10280.t3 VDD pfet_03v3 ad=1.78p pd=8.89u as=1.78p ps=8.89u w=4u l=0.28u
X3 VDD a_3080_10280.t9 a_3080_10280.t8 VDD pfet_03v3 ad=1.78p pd=8.89u as=1.06p ps=4.53u w=4u l=2u
X4 a_14005_19520# a_13929_20389# VSS VSS nfet_03v3 ad=1.06p pd=4.53u as=1.78p ps=8.89u w=4u l=0.28u
X5 a_3181_19520# a_3181_19520# a_16621_24140# VSS nfet_03v3 ad=0.795p pd=3.53u as=0.795p ps=3.53u w=3u l=1u
X6 a_11625_10622# REFCK VDD VDD pfet_03v3 ad=0.89p pd=4.89u as=0.89p ps=4.89u w=2u l=0.28u
X7 a_3080_10280.t20 a_3080_10280.t19 VDD VDD pfet_03v3 ad=1.06p pd=4.53u as=1.06p ps=4.53u w=4u l=2u
X8 a_2169_14900# a_2169_14900# VSS VSS nfet_03v3 ad=0.89p pd=4.89u as=0.89p ps=4.89u w=2u l=2u
X9 VSS VTN.t0 a_7280_5800# VSS nfet_03v3 ad=2.12p pd=8.53u as=2.12p ps=8.53u w=8u l=2u
X10 VSS VTN.t0 a_16621_24140# VSS nfet_03v3 ad=2.12p pd=8.53u as=2.12p ps=8.53u w=8u l=2u
X11 a_4905_10280.t0 a_2169_14900# VSS VSS nfet_03v3 ad=0.89p pd=4.89u as=0.89p ps=4.89u w=2u l=2u
X12 a_1749_20389.t0 a_2169_14900# VSS VSS nfet_03v3 ad=0.53p pd=2.53u as=0.89p ps=4.89u w=2u l=2u
X13 a_6720_24379# a_1545_10280.t3 VTN.t0 VDD pfet_03v3 ad=3.56p pd=16.89u as=2.12p ps=8.53u w=8u l=2u
X14 a_1545_1460# a_1427_2049# VSS VSS nfet_03v3 ad=0.445p pd=2.89u as=0.445p ps=2.89u w=1u l=0.28u
X15 a_11927_6529# a_11927_6529# VSS VSS nfet_03v3 ad=0.445p pd=2.89u as=0.445p ps=2.89u w=1u l=0.28u
X16 a_3080_10280.t14 a_3080_10280.t13 VDD VDD pfet_03v3 ad=1.06p pd=4.53u as=1.06p ps=4.53u w=4u l=2u
X17 a_7280_5800# a_3080_10280.t29 a_3080_10280.t28 VSS nfet_03v3 ad=1.335p pd=6.89u as=0.795p ps=3.53u w=3u l=1u
X18 a_3080_10280.t28 a_3080_10280.t27 a_7280_5800# VSS nfet_03v3 ad=0.795p pd=3.53u as=1.335p ps=6.89u w=3u l=1u
X19 a_6720_24379# PB VDD VDD pfet_03v3 ad=1.06p pd=4.53u as=1.78p ps=8.89u w=4u l=2u
X20 a_3080_10280.t17 a_3080_10280.t16 VDD VDD pfet_03v3 ad=1.06p pd=4.53u as=1.78p ps=8.89u w=4u l=2u
X21 a_1427_6529# a_3225_1460# VSS VSS nfet_03v3 ad=0.445p pd=2.89u as=0.445p ps=2.89u w=1u l=0.28u
X22 a_16665_10622# a_13305_10622# VDD VDD pfet_03v3 ad=0.89p pd=4.89u as=0.89p ps=4.89u w=2u l=0.28u
X23 a_13305_10622# a_1427_6529# VSS VSS nfet_03v3 ad=0.445p pd=2.89u as=0.445p ps=2.89u w=1u l=0.28u
X24 a_3181_19520# a_3181_19520# VDD VDD pfet_03v3 ad=1.06p pd=4.53u as=1.06p ps=4.53u w=4u l=2u
X25 VSS VTN.t0 a_7280_5800# VSS nfet_03v3 ad=3.56p pd=16.89u as=2.12p ps=8.53u w=8u l=2u
X26 VSS VTN.t0 a_16621_24140# VSS nfet_03v3 ad=2.12p pd=8.53u as=2.12p ps=8.53u w=8u l=2u
X27 VDD a_1749_20389.t4 a_1749_20389.t5 VDD pfet_03v3 ad=1.06p pd=4.53u as=1.06p ps=4.53u w=4u l=2u
X28 VSS VTN.t0 a_16621_24140# VSS nfet_03v3 ad=2.12p pd=8.53u as=2.12p ps=8.53u w=8u l=2u
X29 a_1400_10280.t6 VSS cap_mim_2f0_m4m5_noshield c_width=40u c_length=40u
X30 a_3080_10280.t11 a_3080_10280.t10 VDD VDD pfet_03v3 ad=1.06p pd=4.53u as=1.78p ps=8.89u w=4u l=2u
X31 a_3107_2049# a_11625_10622# VSS VSS nfet_03v3 ad=0.445p pd=2.89u as=0.445p ps=2.89u w=1u l=0.28u
X32 VDD a_3080_10280.t22 a_3080_10280.t23 VDD pfet_03v3 ad=1.06p pd=4.53u as=1.06p ps=4.53u w=4u l=2u
X33 VTN.t0 a_1749_20389.t10 a_6720_24379# VDD pfet_03v3 ad=2.12p pd=8.53u as=2.12p ps=8.53u w=8u l=2u
X34 a_1427_2049# a_16665_10622# VSS VSS nfet_03v3 ad=0.445p pd=2.89u as=0.445p ps=2.89u w=1u l=0.28u
X35 a_4760_10280.t1 a_1427_6529# a_3080_10280.t33 VDD pfet_03v3 ad=1.78p pd=8.89u as=1.78p ps=8.89u w=4u l=0.28u
X36 VDD a_3181_19520# a_3181_19520# VDD pfet_03v3 ad=1.06p pd=4.53u as=1.06p ps=4.53u w=4u l=2u
X37 a_13725_6142# a_11927_6529# VDD VDD pfet_03v3 ad=0.445p pd=2.89u as=0.445p ps=2.89u w=1u l=0.28u
X38 a_1400_10280.t4 a_14005_19520# cap_mim_2f0_m4m5_noshield c_width=20u c_length=20u
X39 a_1749_20389.t0 a_3181_19520# VDD VDD pfet_03v3 ad=1.06p pd=4.53u as=1.78p ps=8.89u w=4u l=2u
X40 a_1749_15769# a_1749_15769# VDD VDD pfet_03v3 ad=1.78p pd=8.89u as=1.78p ps=8.89u w=4u l=2u
X41 a_16621_24140# VTN.t0 VSS VSS nfet_03v3 ad=2.12p pd=8.53u as=2.12p ps=8.53u w=8u l=2u
X42 a_1749_20389.t7 a_1749_20389.t4 VDD VDD pfet_03v3 ad=1.06p pd=4.53u as=1.06p ps=4.53u w=4u l=2u
X43 a_1427_2049# a_16665_10622# VDD VDD pfet_03v3 ad=0.89p pd=4.89u as=0.89p ps=4.89u w=2u l=0.28u
X44 VSS VTN.t0 a_7280_5800# VSS nfet_03v3 ad=2.12p pd=8.53u as=2.12p ps=8.53u w=8u l=2u
X45 VDD a_1749_20389.t4 a_3181_19520# VDD pfet_03v3 ad=1.06p pd=4.53u as=1.06p ps=4.53u w=4u l=2u
X46 BWN.t0 a_15405_6142# VSS VSS nfet_03v3 ad=0.445p pd=2.89u as=0.445p ps=2.89u w=1u l=0.28u
X47 a_16621_24140# a_1749_20389.t3 a_1749_20389.t2 VSS nfet_03v3 ad=0.795p pd=3.53u as=0.795p ps=3.53u w=3u l=1u
X48 a_1427_6529# a_3225_1460# VDD VDD pfet_03v3 ad=0.89p pd=4.89u as=0.89p ps=4.89u w=2u l=0.28u
X49 a_13305_10622# REFCK VSS VSS nfet_03v3 ad=0.445p pd=2.89u as=0.445p ps=2.89u w=1u l=0.28u
X50 VSS VTN.t0 a_16621_24140# VSS nfet_03v3 ad=2.12p pd=8.53u as=2.12p ps=8.53u w=8u l=2u
X51 VTN.t1 VSS cap_mim_2f0_m4m5_noshield c_width=70.71u c_length=70.71u
X52 a_7209_24379# a_4905_10280.t4 a_6720_24379# VDD pfet_03v3 ad=2.12p pd=8.53u as=3.56p ps=16.89u w=8u l=2u
X53 a_13929_20389# BWK.t1 VDD VDD pfet_03v3 ad=0.89p pd=4.89u as=0.89p ps=4.89u w=2u l=0.28u
X54 a_3080_10280.t8 a_3080_10280.t7 VDD VDD pfet_03v3 ad=1.06p pd=4.53u as=1.06p ps=4.53u w=4u l=2u
X55 a_2169_14900# a_1749_15769# VDD VDD pfet_03v3 ad=1.78p pd=8.89u as=1.78p ps=8.89u w=4u l=2u
X56 a_15405_6142# a_13725_6142# VSS VSS nfet_03v3 ad=0.445p pd=2.89u as=0.445p ps=2.89u w=1u l=0.28u
X57 a_1545_1460# a_1427_2049# VDD VDD pfet_03v3 ad=0.89p pd=4.89u as=0.89p ps=4.89u w=2u l=0.28u
X58 VDD a_3080_10280.t22 a_3080_10280.t25 VDD pfet_03v3 ad=1.78p pd=8.89u as=1.06p ps=4.53u w=4u l=2u
X59 a_1545_10280.t0 a_1545_1460# a_1400_10280.t2 VSS nfet_03v3 ad=0.89p pd=4.89u as=0.89p ps=4.89u w=2u l=0.28u
X60 a_1545_6142# a_1427_6529# VSS VSS nfet_03v3 ad=0.445p pd=2.89u as=0.445p ps=2.89u w=1u l=0.28u
X61 VDD a_1749_15769# a_3181_19520# VDD pfet_03v3 ad=1.06p pd=4.53u as=1.06p ps=4.53u w=4u l=2u
X62 a_7280_5800# VTN.t0 VSS VSS nfet_03v3 ad=2.12p pd=8.53u as=2.12p ps=8.53u w=8u l=2u
X63 VSS a_7209_24379# a_7209_24379# VSS nfet_03v3 ad=1.06p pd=4.53u as=1.06p ps=4.53u w=4u l=2u
X64 a_4760_10280.t4 a_25529_24140# cap_mim_2f0_m4m5_noshield c_width=20u c_length=20u
X65 a_1749_20389.t0 a_2169_14900# VSS VSS nfet_03v3 ad=0.53p pd=2.53u as=0.53p ps=2.53u w=2u l=2u
X66 a_3107_2049# a_1427_2049# a_22125_19520# VDD pfet_03v3 ad=1.78p pd=8.89u as=1.78p ps=8.89u w=4u l=0.28u
X67 a_7280_5800# VTN.t0 VSS VSS nfet_03v3 ad=2.12p pd=8.53u as=2.12p ps=8.53u w=8u l=2u
X68 a_16621_24140# VTN.t0 VSS VSS nfet_03v3 ad=2.12p pd=8.53u as=2.12p ps=8.53u w=8u l=2u
X69 VTN.t0 a_1545_10280.t4 a_6720_24379# VDD pfet_03v3 ad=2.12p pd=8.53u as=2.12p ps=8.53u w=8u l=2u
X70 VDD a_1749_20389.t4 a_3181_19520# VDD pfet_03v3 ad=1.06p pd=4.53u as=1.06p ps=4.53u w=4u l=2u
X71 a_3080_10280.t5 a_3080_10280.t4 VDD VDD pfet_03v3 ad=1.06p pd=4.53u as=1.78p ps=8.89u w=4u l=2u
X72 VDD a_3181_19520# a_1749_20389.t0 VDD pfet_03v3 ad=1.78p pd=8.89u as=1.06p ps=4.53u w=4u l=2u
X73 a_1545_6142# a_1427_6529# VDD VDD pfet_03v3 ad=0.89p pd=4.89u as=0.89p ps=4.89u w=2u l=0.28u
X74 a_1749_15769# NB VSS VSS nfet_03v3 ad=0.445p pd=2.89u as=0.445p ps=2.89u w=1u l=4u
X75 VDD PB a_6720_24379# VDD pfet_03v3 ad=1.78p pd=8.89u as=1.06p ps=4.53u w=4u l=2u
X76 a_3181_19520# a_3181_19520# VDD VDD pfet_03v3 ad=1.06p pd=4.53u as=1.06p ps=4.53u w=4u l=2u
X77 a_17085_1460# BWN.t1 VDD VDD pfet_03v3 ad=0.89p pd=4.89u as=0.89p ps=4.89u w=2u l=0.28u
X78 VDD a_3080_10280.t18 a_3080_10280.t17 VDD pfet_03v3 ad=1.06p pd=4.53u as=1.06p ps=4.53u w=4u l=2u
X79 BWK.t0 a_15405_6142# VSS VSS nfet_03v3 ad=0.445p pd=2.89u as=0.445p ps=2.89u w=1u l=0.28u
X80 a_3225_1460# a_3107_2049# VDD VDD pfet_03v3 ad=0.89p pd=4.89u as=0.89p ps=4.89u w=2u l=0.28u
X81 a_4905_10280.t1 a_1427_2049# a_4760_10280.t2 VDD pfet_03v3 ad=1.78p pd=8.89u as=1.78p ps=8.89u w=4u l=0.28u
X82 VDD a_1749_15769# a_3181_19520# VDD pfet_03v3 ad=1.78p pd=8.89u as=1.06p ps=4.53u w=4u l=2u
X83 a_7280_5800# VTN.t0 VSS VSS nfet_03v3 ad=2.12p pd=8.53u as=3.56p ps=16.89u w=8u l=2u
X84 VSS a_7209_24379# VTN.t0 VSS nfet_03v3 ad=1.78p pd=8.89u as=1.06p ps=4.53u w=4u l=2u
X85 a_7209_24379# a_3181_19520# a_6720_24379# VDD pfet_03v3 ad=2.12p pd=8.53u as=3.56p ps=16.89u w=8u l=2u
X86 VSS a_2169_14900# a_1749_20389.t0 VSS nfet_03v3 ad=0.53p pd=2.53u as=0.53p ps=2.53u w=2u l=2u
X87 a_3080_10280.t31 a_3080_10280.t30 a_7280_5800# VSS nfet_03v3 ad=0.795p pd=3.53u as=1.335p ps=6.89u w=3u l=1u
X88 a_7280_5800# VTN.t0 VSS VSS nfet_03v3 ad=2.12p pd=8.53u as=2.12p ps=8.53u w=8u l=2u
X89 a_4905_10280.t0 a_1545_1460# a_4760_10280.t0 VSS nfet_03v3 ad=0.89p pd=4.89u as=0.89p ps=4.89u w=2u l=0.28u
X90 VDD a_3080_10280.t12 a_3080_10280.t11 VDD pfet_03v3 ad=1.06p pd=4.53u as=1.06p ps=4.53u w=4u l=2u
X91 a_22125_19520# a_11625_10622# VDD VDD pfet_03v3 ad=1.78p pd=8.89u as=1.78p ps=8.89u w=4u l=0.28u
X92 a_3080_10280.t37 VSS cap_mim_2f0_m4m5_noshield c_width=30u c_length=30u
X93 a_13929_20389# BWK.t2 VSS VSS nfet_03v3 ad=0.445p pd=2.89u as=0.445p ps=2.89u w=1u l=0.28u
X94 a_1400_10280.t5 a_25205_24140# cap_mim_2f0_m4m5_noshield c_width=20u c_length=20u
X95 a_11625_10622# REFCK VSS VSS nfet_03v3 ad=0.445p pd=2.89u as=0.445p ps=2.89u w=1u l=0.28u
X96 a_1545_10280.t0 a_1749_15769# VDD VDD pfet_03v3 ad=1.78p pd=8.89u as=1.78p ps=8.89u w=4u l=2u
X97 a_3080_10280.t25 a_3080_10280.t22 VDD VDD pfet_03v3 ad=1.06p pd=4.53u as=1.06p ps=4.53u w=4u l=2u
X98 a_4905_10280.t2 a_3080_10280.t35 cap_mim_2f0_m4m5_noshield c_width=50u c_length=50u
X99 a_3225_1460# a_3107_2049# VSS VSS nfet_03v3 ad=0.445p pd=2.89u as=0.445p ps=2.89u w=1u l=0.28u
X100 VDD a_3080_10280.t21 a_3080_10280.t20 VDD pfet_03v3 ad=1.78p pd=8.89u as=1.06p ps=4.53u w=4u l=2u
X101 a_25529_24140# a_17085_1460# VSS VSS nfet_03v3 ad=1.06p pd=4.53u as=1.06p ps=4.53u w=4u l=0.28u
X102 a_1545_10280.t2 a_3080_10280.t0 cap_mim_2f0_m4m5_noshield c_width=50u c_length=50u
X103 VSS a_2169_14900# a_1749_20389.t0 VSS nfet_03v3 ad=0.89p pd=4.89u as=0.53p ps=2.53u w=2u l=2u
X104 a_3181_19520# a_1749_20389.t4 VDD VDD pfet_03v3 ad=1.06p pd=4.53u as=1.06p ps=4.53u w=4u l=2u
X105 VDD a_1749_20389.t4 a_1749_20389.t7 VDD pfet_03v3 ad=1.78p pd=8.89u as=1.06p ps=4.53u w=4u l=2u
X106 a_14329_19520# a_13929_20389# VSS VSS nfet_03v3 ad=1.06p pd=4.53u as=1.06p ps=4.53u w=4u l=0.28u
X107 a_20300_19520# REFCK VDD VDD pfet_03v3 ad=1.78p pd=8.89u as=1.78p ps=8.89u w=4u l=0.28u
X108 a_16621_24140# VTN.t0 VSS VSS nfet_03v3 ad=2.12p pd=8.53u as=2.12p ps=8.53u w=8u l=2u
X109 a_4760_10280.t3 a_14329_19520# cap_mim_2f0_m4m5_noshield c_width=20u c_length=20u
X110 a_7280_5800# a_3080_10280.t32 a_3080_10280.t31 VSS nfet_03v3 ad=1.335p pd=6.89u as=0.795p ps=3.53u w=3u l=1u
X111 a_1400_10280.t1 a_1427_6529# a_3080_10280.t34 VDD pfet_03v3 ad=1.78p pd=8.89u as=1.78p ps=8.89u w=4u l=0.28u
X112 a_4760_10280.t0 a_1545_6142# a_3080_10280.t2 VSS nfet_03v3 ad=0.89p pd=4.89u as=0.89p ps=4.89u w=2u l=0.28u
X113 a_3080_10280.t23 a_3080_10280.t22 VDD VDD pfet_03v3 ad=1.06p pd=4.53u as=1.78p ps=8.89u w=4u l=2u
X114 a_17085_1460# BWN.t2 VSS VSS nfet_03v3 ad=0.445p pd=2.89u as=0.445p ps=2.89u w=1u l=0.28u
X115 a_1749_20389.t2 a_1749_20389.t1 a_16621_24140# VSS nfet_03v3 ad=0.795p pd=3.53u as=1.335p ps=6.89u w=3u l=1u
X116 VDD a_3181_19520# a_1749_20389.t0 VDD pfet_03v3 ad=1.06p pd=4.53u as=1.06p ps=4.53u w=4u l=2u
X117 a_1400_10280.t0 a_1545_6142# a_3080_10280.t3 VSS nfet_03v3 ad=0.89p pd=4.89u as=0.89p ps=4.89u w=2u l=0.28u
X118 a_3181_19520# a_1749_15769# VDD VDD pfet_03v3 ad=1.06p pd=4.53u as=1.06p ps=4.53u w=4u l=2u
X119 VTN.t0 a_7209_24379# VSS VSS nfet_03v3 ad=1.06p pd=4.53u as=1.06p ps=4.53u w=4u l=2u
X120 a_1749_20389.t5 a_1749_20389.t4 VDD VDD pfet_03v3 ad=1.06p pd=4.53u as=1.78p ps=8.89u w=4u l=2u
X121 VSS a_17085_1460# a_25205_24140# VSS nfet_03v3 ad=1.06p pd=4.53u as=1.06p ps=4.53u w=4u l=0.28u
X122 a_3181_19520# a_1749_20389.t4 VDD VDD pfet_03v3 ad=1.06p pd=4.53u as=1.06p ps=4.53u w=4u l=2u
X123 VSS a_13929_20389# a_14005_19520# VSS nfet_03v3 ad=1.06p pd=4.53u as=1.06p ps=4.53u w=4u l=0.28u
X124 a_16621_24140# VTN.t0 VSS VSS nfet_03v3 ad=2.12p pd=8.53u as=2.12p ps=8.53u w=8u l=2u
X125 VSS a_17085_1460# a_25529_24140# VSS nfet_03v3 ad=1.78p pd=8.89u as=1.06p ps=4.53u w=4u l=0.28u
X126 a_6720_24379# a_4905_10280.t3 a_7209_24379# VDD pfet_03v3 ad=2.12p pd=8.53u as=2.12p ps=8.53u w=8u l=2u
X127 VDD a_3080_10280.t6 a_3080_10280.t5 VDD pfet_03v3 ad=1.06p pd=4.53u as=1.06p ps=4.53u w=4u l=2u
X128 a_25205_24140# a_17085_1460# VSS VSS nfet_03v3 ad=1.06p pd=4.53u as=1.78p ps=8.89u w=4u l=0.28u
X129 a_16665_10622# a_13305_10622# VSS VSS nfet_03v3 ad=0.445p pd=2.89u as=0.445p ps=2.89u w=1u l=0.28u
X130 a_13305_10622# a_1427_6529# a_20300_19520# VDD pfet_03v3 ad=1.78p pd=8.89u as=1.78p ps=8.89u w=4u l=0.28u
X131 VSS a_13929_20389# a_14329_19520# VSS nfet_03v3 ad=1.78p pd=8.89u as=1.06p ps=4.53u w=4u l=0.28u
X132 VSS VTN.t0 a_7280_5800# VSS nfet_03v3 ad=2.12p pd=8.53u as=2.12p ps=8.53u w=8u l=2u
X133 a_3181_19520# a_1749_15769# VDD VDD pfet_03v3 ad=1.06p pd=4.53u as=1.78p ps=8.89u w=4u l=2u
X134 a_7209_24379# a_7209_24379# VSS VSS nfet_03v3 ad=1.06p pd=4.53u as=1.78p ps=8.89u w=4u l=2u
X135 VDD a_3181_19520# a_3181_19520# VDD pfet_03v3 ad=1.06p pd=4.53u as=1.06p ps=4.53u w=4u l=2u
X136 VDD a_3080_10280.t15 a_3080_10280.t14 VDD pfet_03v3 ad=1.78p pd=8.89u as=1.06p ps=4.53u w=4u l=2u
X137 a_3107_2049# a_1427_2049# VSS VSS nfet_03v3 ad=0.445p pd=2.89u as=0.445p ps=2.89u w=1u l=0.28u
X138 a_6720_24379# a_3181_19520# a_7209_24379# VDD pfet_03v3 ad=2.12p pd=8.53u as=2.12p ps=8.53u w=8u l=2u
X139 a_16621_24140# a_3181_19520# a_3181_19520# VSS nfet_03v3 ad=1.335p pd=6.89u as=0.795p ps=3.53u w=3u l=1u
X140 a_4760_10280.t5 VSS cap_mim_2f0_m4m5_noshield c_width=40u c_length=40u
C0 a_3181_19520# a_26398_19460# 0.01073f
C1 a_10460_24319# VTN 0.02535f
C2 a_3225_1460# a_2169_14900# 2.15942f
C3 a_1427_2049# a_3225_1460# 0.08994f
C4 PB REFCK 0.03384f
C5 a_4020_14840# a_2169_14900# 0.01707f
C6 a_23544_19460# a_23954_19460# 0.0129f
C7 a_1427_6529# BWN 0.03546f
C8 REFCK a_11625_10622# 0.15385f
C9 BWK a_4958_6082# 0.06961f
C10 a_7280_5800# a_13076_24319# 0.02093f
C11 a_1427_6529# a_1749_15769# 0.66558f
C12 a_1545_1460# a_11625_10622# 0.04252f
C13 a_23436_14840# a_1749_15769# 0.05273f
C14 a_25205_24140# a_25529_24140# 2.89224f
C15 a_7280_5800# a_14329_19520# 0.03317f
C16 a_7280_5800# BWN 0.03184f
C17 a_8024_5740# BWK 0.0283f
C18 VDD a_6734_10220# 0.58509f
C19 a_6720_24379# VTN 0.25161f
C20 a_27116_32719# a_16621_24140# 0.06437f
C21 a_7280_5800# a_1749_15769# 0.03518f
C22 a_1749_15769# a_13305_10622# 0.0412f
C23 a_8220_14840# a_1749_15769# 0.04794f
C24 a_23954_5740# a_11625_10622# 0.01988f
C25 a_1284_1400# VDD 0.36665f
C26 a_1427_6529# a_1545_6142# 0.70234f
C27 a_14005_19520# a_13929_20389# 0.14746f
C28 a_3181_19520# a_14329_19520# 0.2782f
C29 a_3374_1400# VDD 0.34678f
C30 a_22274_19460# a_22125_19520# 0.0476f
C31 a_10836_14840# a_1749_15769# 0.04794f
C32 a_2318_14840# a_1749_15769# 0.0782f
C33 a_18494_10562# a_16665_10622# 0.0121f
C34 a_7209_24379# a_14005_19520# 0.03557f
C35 a_3181_19520# a_1749_15769# 1.05077f
C36 BWN a_3107_2049# 0.03546f
C37 a_25529_24140# a_17085_1460# 0.19701f
C38 VTN a_20300_19520# 0.07686f
C39 a_1694_1400# a_1545_1460# 0.02481f
C40 a_17085_1460# a_16665_10622# 0.03431f
C41 a_3181_19520# a_25300_19460# 0.01156f
C42 a_3107_2049# a_1749_15769# 0.11024f
C43 a_16814_10562# a_16665_10622# 0.01868f
C44 a_2964_10220# VDD 0.58317f
C45 a_15554_6082# a_15405_6142# 0.01226f
C46 BWN BWK 8.36742f
C47 a_18580_1400# a_1545_1460# 0.0227f
C48 a_1427_2049# a_16665_10622# 1.25637f
C49 a_2964_1400# VDD 0.36377f
C50 BWN REFCK 0.21929f
C51 BWK a_1749_15769# 0.29171f
C52 a_1545_1460# a_20174_10562# 0.01149f
C53 a_1545_6142# a_3107_2049# 0.04457f
C54 a_7280_5800# VTN 2.99515f
C55 REFCK a_1749_15769# 0.04359f
C56 BWN a_1545_1460# 0.2777f
C57 PB a_5860_19460# 0.02897f
C58 VDD a_19236_14840# 1.94361f
C59 a_25205_24140# a_20300_19520# 0.0508f
C60 a_3374_1400# a_3225_1460# 0.02481f
C61 a_20184_19460# VDD 0.5834f
C62 a_27594_24080# VDD 0.60458f
C63 a_20820_14840# VDD 1.94361f
C64 BWK a_1545_6142# 0.1502f
C65 a_1427_6529# NB 0.04359f
C66 a_1220_19460# PB 0.02897f
C67 a_3181_19520# VTN 0.04991f
C68 a_12160_19460# VDD 1.92027f
C69 VDD a_13929_20389# 1.94992f
C70 VDD a_15405_6142# 0.13989f
C71 a_11927_6529# a_13725_6142# 0.01689f
C72 a_1545_1460# a_10880_1400# 0.02758f
C73 a_6720_24379# a_2169_14900# 0.53551f
C74 a_1427_2049# a_6720_24379# 0.04089f
C75 a_3225_1460# VDD 1.81343f
C76 VDD a_4020_14840# 1.94306f
C77 a_6324_1400# VDD 0.36295f
C78 a_6734_1400# a_1545_6142# 0.01989f
C79 VDD a_4644_10220# 0.58317f
C80 BWK a_13725_6142# 0.05795f
C81 a_25214_10562# a_3225_1460# 0.01256f
C82 a_7209_24379# VDD 0.97439f
C83 a_1545_1460# a_1545_6142# 0.30449f
C84 a_17085_1460# a_20300_19520# 0.05902f
C85 REFCK a_13725_6142# 0.11541f
C86 a_1427_6529# a_26894_10562# 0.01149f
C87 a_1427_6529# a_17085_1460# 0.04028f
C88 BWN PB 3.6254f
C89 a_21854_10562# a_3107_2049# 0.01156f
C90 a_25020_14840# a_1749_15769# 0.05455f
C91 a_13874_6082# VDD 0.21429f
C92 PB a_1749_15769# 0.03925f
C93 VDD a_23954_19460# 0.58576f
C94 VDD a_13464_6082# 0.2246f
C95 a_3060_6082# a_1749_15769# 0.03377f
C96 NB a_3107_2049# 0.49681f
C97 a_1749_15769# a_11625_10622# 0.08784f
C98 a_15144_1400# VDD 0.36583f
C99 a_1427_6529# a_2169_14900# 0.03998f
C100 a_13929_20389# a_15405_6142# 0.08111f
C101 a_17085_1460# a_13305_10622# 0.0361f
C102 a_1427_2049# a_1427_6529# 2.69248f
C103 a_6734_10220# a_6324_10220# 0.0129f
C104 a_1427_2049# a_23436_14840# 0.03735f
C105 a_3225_1460# a_13929_20389# 0.05025f
C106 a_22274_19460# VDD 0.60202f
C107 a_4958_6082# a_1749_15769# 0.03192f
C108 a_7520_19460# VDD 1.9099f
C109 a_8080_1400# a_3225_1460# 0.01052f
C110 BWK NB 2.01768f
C111 a_23544_19460# a_3107_2049# 0.01569f
C112 a_7280_5800# a_2169_14900# 0.03791f
C113 a_1427_2049# a_13305_10622# 0.30288f
C114 a_16620_14840# a_1749_15769# 0.04794f
C115 a_3060_6082# a_1545_6142# 0.01497f
C116 a_1427_2049# a_7280_5800# 0.03667f
C117 a_1427_6529# a_5054_1400# 0.02481f
C118 a_3181_19520# a_17085_1460# 0.13926f
C119 a_8220_14840# a_2169_14900# 0.01742f
C120 NB REFCK 0.04359f
C121 a_1427_6529# a_3374_10220# 0.01118f
C122 a_26398_19460# a_1749_15769# 0.12204f
C123 a_17085_1460# a_3107_2049# 0.10938f
C124 a_2318_14840# a_2169_14900# 0.15698f
C125 a_3181_19520# a_22125_19520# 0.01781f
C126 a_25529_24140# VDD 0.25621f
C127 a_4958_6082# a_1545_6142# 0.0173f
C128 a_16665_10622# VDD 1.39793f
C129 a_1427_2049# a_3181_19520# 0.05474f
C130 a_16621_24140# VTN 3.09312f
C131 VDD a_6324_10220# 0.5834f
C132 a_1694_10220# a_1284_10220# 0.0129f
C133 a_22125_19520# a_3107_2049# 0.38073f
C134 a_10460_24319# VDD 3.01703f
C135 a_27184_24080# VDD 0.6348f
C136 a_3107_2049# a_2169_14900# 0.03761f
C137 a_1427_2049# a_3107_2049# 2.2965f
C138 a_11774_10562# a_11625_10622# 0.01511f
C139 a_17085_1460# REFCK 0.03939f
C140 a_6260_24319# VDD 3.01703f
C141 a_18084_10562# a_16665_10622# 0.01112f
C142 a_12420_14840# a_1749_15769# 0.04794f
C143 a_7280_5800# a_14005_19520# 0.03791f
C144 BWK a_2169_14900# 0.10948f
C145 a_8876_24319# VTN 0.0276f
C146 a_1427_2049# BWK 0.03986f
C147 a_17085_1460# a_1545_1460# 0.23062f
C148 BWN a_1749_15769# 0.03546f
C149 a_25205_24140# a_16621_24140# 0.17881f
C150 VDD a_26118_14840# 1.85265f
C151 a_6720_24379# VDD 3.9328f
C152 REFCK a_2169_14900# 0.03384f
C153 VTN a_14660_24080# 0.03008f
C154 a_1427_2049# REFCK 0.12743f
C155 a_27594_24080# a_27184_24080# 0.0129f
C156 a_1694_6082# a_1545_6142# 0.01386f
C157 a_3181_19520# a_14005_19520# 0.04718f
C158 a_1545_1460# a_2169_14900# 1.05049f
C159 a_1427_2049# a_1545_1460# 0.05289f
C160 a_16665_10622# a_3225_1460# 0.40868f
C161 a_25300_19460# a_1749_15769# 0.05703f
C162 a_13305_10622# a_15134_10562# 0.01888f
C163 BWN a_1545_6142# 0.04592f
C164 a_10460_24319# a_7209_24379# 0.01862f
C165 VDD a_20300_19520# 1.42818f
C166 a_1427_2049# a_1694_10220# 0.01233f
C167 a_1545_6142# a_1749_15769# 0.11503f
C168 a_9178_1400# a_2169_14900# 0.06418f
C169 a_13076_24319# VTN 0.0276f
C170 a_1427_6529# VDD 4.34243f
C171 a_23436_14840# VDD 1.94361f
C172 a_1427_6529# a_2964_10220# 0.01439f
C173 a_17085_1460# a_11625_10622# 0.58912f
C174 a_12194_6082# a_11927_6529# 0.01636f
C175 a_6720_24379# a_7209_24379# 0.66542f
C176 a_20184_19460# a_20300_19520# 0.04076f
C177 a_22125_19520# a_11625_10622# 0.11984f
C178 VDD a_13305_10622# 2.0826f
C179 a_27594_24080# a_20300_19520# 0.04068f
C180 a_7280_5800# VDD 1.47387f
C181 PB a_2169_14900# 0.9615f
C182 VDD a_8220_14840# 1.94361f
C183 a_1427_2049# PB 0.07501f
C184 a_1427_2049# a_11625_10622# 0.08151f
C185 a_1427_6529# a_20184_19460# 0.01752f
C186 a_10836_14840# VDD 1.94361f
C187 a_2318_14840# VDD 1.83104f
C188 a_25634_5740# VDD 0.3476f
C189 a_3181_19520# VDD 15.6499f
C190 a_1427_6529# a_13929_20389# 0.05983f
C191 BWN NB 0.07611f
C192 a_20184_19460# a_13305_10622# 0.01153f
C193 VDD a_3107_2049# 2.69864f
C194 a_15554_1400# VDD 0.34678f
C195 a_1427_6529# a_3225_1460# 0.26443f
C196 NB a_1749_15769# 0.30821f
C197 a_11927_6529# VDD 0.58099f
C198 a_13305_10622# a_13929_20389# 0.03198f
C199 a_17085_1460# a_18580_1400# 0.03962f
C200 BWK VDD 1.15753f
C201 a_1427_2049# a_27314_5740# 0.01988f
C202 a_23348_24080# a_20300_19520# 0.01862f
C203 a_19678_1400# a_1545_1460# 0.01884f
C204 a_3225_1460# a_13305_10622# 0.95204f
C205 a_15036_14840# a_1749_15769# 0.04794f
C206 a_7280_5800# a_7209_24379# 1.17123f
C207 REFCK VDD 5.20085f
C208 a_17085_1460# BWN 0.04851f
C209 a_3181_19520# a_12160_19460# 0.01558f
C210 NB a_1545_6142# 0.01755f
C211 a_3181_19520# a_13929_20389# 0.06784f
C212 a_6734_1400# VDD 0.34967f
C213 a_1545_1460# VDD 1.96951f
C214 a_17085_1460# a_1749_15769# 0.11495f
C215 a_7280_5800# a_10404_5740# 0.0834f
C216 a_14660_24080# a_14005_19520# 0.06336f
C217 a_3107_2049# a_13929_20389# 0.02568f
C218 a_3181_19520# a_7209_24379# 0.75452f
C219 a_15554_1400# a_13929_20389# 0.02481f
C220 a_10460_24319# a_6720_24379# 0.23918f
C221 BWN a_2169_14900# 0.11099f
C222 a_1427_2049# BWN 0.03741f
C223 VDD a_8080_10220# 1.95466f
C224 a_3225_1460# a_3107_2049# 0.15048f
C225 a_23544_5740# VDD 0.36295f
C226 a_1694_10220# VDD 0.58546f
C227 a_23954_5740# VDD 0.35048f
C228 a_27594_24080# REFCK 0.01003f
C229 a_6636_14840# a_1749_15769# 0.04794f
C230 a_1749_15769# a_2169_14900# 0.31797f
C231 a_3181_19520# a_18536_19460# 0.01194f
C232 a_6260_24319# a_6720_24379# 0.21789f
C233 a_9684_10220# VDD 1.95466f
C234 a_1427_2049# a_1749_15769# 0.07939f
C235 BWK a_13929_20389# 1.03726f
C236 a_25205_24140# VTN 0.03803f
C237 a_25529_24140# a_20300_19520# 0.06848f
C238 BWK a_15405_6142# 0.12009f
C239 a_17085_1460# a_1545_6142# 0.03764f
C240 REFCK a_13929_20389# 0.96432f
C241 REFCK a_15405_6142# 0.31191f
C242 a_25224_5740# VDD 0.36583f
C243 a_27184_24080# a_20300_19520# 0.01601f
C244 a_16621_24140# VDD 0.33039f
C245 a_3225_1460# REFCK 0.03676f
C246 a_1427_6529# a_16665_10622# 0.18729f
C247 VDD a_25020_14840# 1.94361f
C248 a_1545_1460# a_13929_20389# 0.16616f
C249 a_1427_6529# a_6324_10220# 0.0175f
C250 a_1545_6142# a_2169_14900# 2.08783f
C251 a_1427_2049# a_1545_6142# 0.04143f
C252 a_17085_1460# a_24944_24080# 0.01011f
C253 a_1545_1460# a_3225_1460# 1.01402f
C254 a_23954_19460# a_3107_2049# 0.04066f
C255 PB VDD 5.5394f
C256 a_8080_1400# a_1545_1460# 0.02758f
C257 BWK a_10404_5740# 0.01671f
C258 a_7520_19460# a_3181_19520# 0.02975f
C259 VDD a_11625_10622# 2.54714f
C260 a_14329_19520# a_14005_19520# 0.13805f
C261 a_20594_6082# a_13929_20389# 0.01149f
C262 a_16665_10622# a_13305_10622# 1.6048f
C263 a_8876_24319# VDD 3.01703f
C264 a_10460_24319# a_7280_5800# 0.04527f
C265 a_20594_19460# VDD 0.58512f
C266 VDD a_16620_14840# 1.94361f
C267 VDD a_5860_19460# 1.9099f
C268 a_25634_5740# a_16665_10622# 0.02646f
C269 a_6720_24379# a_1427_6529# 0.0445f
C270 a_17085_1460# a_17234_1400# 0.02481f
C271 a_9178_1400# a_3225_1460# 0.01052f
C272 a_26398_19460# VDD 1.85265f
C273 a_13496_1400# a_3225_1460# 0.01052f
C274 a_21864_19460# VDD 0.63706f
C275 a_16665_10622# a_3107_2049# 0.23976f
C276 a_1220_19460# VDD 1.9099f
C277 a_25205_24140# a_17085_1460# 0.14313f
C278 a_16621_24140# a_7209_24379# 0.05564f
C279 a_27314_5740# VDD 0.35048f
C280 a_26904_5740# VDD 0.36295f
C281 a_6720_24379# a_7280_5800# 0.27996f
C282 a_11625_10622# a_13929_20389# 0.02568f
C283 a_1694_1400# VDD 0.3476f
C284 a_20184_19460# a_20594_19460# 0.0129f
C285 a_1427_2049# a_1284_10220# 0.01149f
C286 a_6260_24319# a_3181_19520# 0.04915f
C287 a_1427_6529# a_20300_19520# 0.09099f
C288 a_23534_10562# a_3107_2049# 0.01351f
C289 NB a_2169_14900# 0.23861f
C290 a_1427_2049# NB 0.04457f
C291 a_16824_1400# VDD 0.36583f
C292 a_13076_24319# VDD 3.01703f
C293 a_16665_10622# REFCK 0.03676f
C294 a_6720_24379# a_3181_19520# 0.93648f
C295 a_12420_14840# VDD 1.94361f
C296 a_8876_24319# a_7209_24379# 0.01993f
C297 VTN a_14005_19520# 0.11579f
C298 a_20300_19520# a_13305_10622# 0.3077f
C299 a_14329_19520# VDD 1.59789f
C300 a_23544_19460# a_22125_19520# 0.04828f
C301 a_1545_1460# a_16665_10622# 0.09641f
C302 a_7280_5800# a_20300_19520# 0.0646f
C303 BWN VDD 1.24733f
C304 a_1427_2049# a_23544_19460# 0.01606f
C305 a_7209_24379# a_14660_24080# 0.01551f
C306 a_1427_2049# a_18494_10562# 0.01151f
C307 a_1427_6529# a_13305_10622# 1.70027f
C308 VDD a_1749_15769# 11.9949f
C309 a_7280_5800# a_1427_6529# 0.03667f
C310 a_22125_19520# a_17085_1460# 0.04359f
C311 a_17085_1460# a_2169_14900# 0.04177f
C312 a_3181_19520# a_20300_19520# 0.17604f
C313 a_1427_2049# a_17085_1460# 0.05921f
C314 a_25300_19460# VDD 1.94915f
C315 a_7520_19460# PB 0.02897f
C316 a_6720_24379# REFCK 0.04066f
C317 NB a_1220_14840# 0.01995f
C318 a_3181_19520# a_1427_6529# 0.05451f
C319 a_25205_24140# a_14005_19520# 1.14015f
C320 a_7280_5800# a_7020_5740# 0.06437f
C321 a_1427_2049# a_22125_19520# 0.10845f
C322 a_1545_6142# VDD 2.90121f
C323 a_13305_10622# a_13454_10562# 0.01511f
C324 a_6636_14840# a_2169_14900# 0.02001f
C325 a_19236_14840# a_1749_15769# 0.04794f
C326 a_16621_24140# a_25529_24140# 0.25361f
C327 a_1427_2049# a_2169_14900# 0.03442f
C328 BWN a_18914_6082# 0.01157f
C329 a_14329_19520# a_12160_19460# 0.05698f
C330 a_1427_6529# a_3107_2049# 0.39256f
C331 a_14329_19520# a_13929_20389# 0.1979f
C332 a_20820_14840# a_1749_15769# 0.05486f
C333 a_13076_24319# a_7209_24379# 0.01557f
C334 BWN a_13929_20389# 0.1045f
C335 BWN a_15405_6142# 0.19237f
C336 a_7280_5800# a_3181_19520# 0.14931f
C337 VDD a_5054_10220# 0.58363f
C338 VDD a_13725_6142# 0.31493f
C339 a_16665_10622# a_11625_10622# 0.10243f
C340 a_1749_15769# a_13929_20389# 0.03446f
C341 REFCK a_20300_19520# 0.1382f
C342 a_1427_6529# BWK 0.10913f
C343 a_22274_19460# a_21864_19460# 0.0129f
C344 a_22274_6082# a_17085_1460# 0.01249f
C345 a_3107_2049# a_13305_10622# 0.05241f
C346 a_7280_5800# a_3107_2049# 0.03234f
C347 a_4020_14840# a_1749_15769# 0.04794f
C348 VTN VDD 2.68958f
C349 a_1427_6529# REFCK 0.19012f
C350 a_1427_6529# a_1545_1460# 0.29267f
C351 a_10880_1400# a_3225_1460# 0.01052f
C352 a_7280_5800# BWK 0.21789f
C353 a_1545_6142# a_13929_20389# 0.03208f
C354 BWK a_7020_5740# 0.0283f
C355 a_1545_6142# a_3225_1460# 1.02643f
C356 a_17234_1400# VDD 0.34678f
C357 REFCK a_13305_10622# 0.12181f
C358 a_6324_1400# a_1545_6142# 0.01041f
C359 a_7280_5800# REFCK 0.03676f
C360 a_6720_24379# PB 0.69382f
C361 VDD a_1284_10220# 0.58576f
C362 a_1427_6529# a_8080_10220# 0.01775f
C363 a_13929_20389# a_13725_6142# 0.09418f
C364 a_15405_6142# a_13725_6142# 0.02788f
C365 a_25205_24140# VDD 0.25621f
C366 a_1427_6529# a_9684_10220# 0.02082f
C367 NB VDD 0.95155f
C368 a_6720_24379# a_8876_24319# 0.27596f
C369 a_5054_10220# a_4644_10220# 0.0129f
C370 a_16621_24140# a_20300_19520# 0.01531f
C371 BWK a_3107_2049# 0.03989f
C372 a_16621_24140# a_25500_32719# 0.06447f
C373 BWK a_11927_6529# 0.14658f
C374 a_7280_5800# a_9400_5740# 0.07458f
C375 REFCK a_3107_2049# 0.02591f
C376 VDD a_15036_14840# 1.94361f
C377 a_23544_19460# VDD 0.58276f
C378 a_7209_24379# VTN 1.5128f
C379 a_1545_1460# a_3107_2049# 0.27528f
C380 a_1427_6529# PB 0.04885f
C381 a_1427_6529# a_11625_10622# 0.06467f
C382 BWK REFCK 1.25019f
C383 a_18536_19460# VTN 0.01427f
C384 a_17085_1460# VDD 2.52792f
C385 a_13874_6082# a_13725_6142# 0.01226f
C386 a_20594_19460# a_20300_19520# 0.01648f
C387 a_7280_5800# a_16621_24140# 1.65266f
C388 a_4644_1400# VDD 0.36495f
C389 a_17234_6082# BWK 0.01657f
C390 BWK a_1545_1460# 0.27193f
C391 a_22125_19520# VDD 0.8585f
C392 a_14640_19460# a_13929_20389# 0.01025f
C393 PB a_8220_14840# 0.01483f
C394 a_13305_10622# a_11625_10622# 0.55308f
C395 VDD a_6636_14840# 1.94361f
C396 VDD a_2169_14900# 2.0183f
C397 a_6720_24379# a_13076_24319# 0.21789f
C398 a_1545_1460# REFCK 0.03167f
C399 a_1427_2049# VDD 4.96772f
C400 NB a_4020_14840# 0.03629f
C401 a_3181_19520# a_16621_24140# 0.48202f
C402 BWK a_9400_5740# 0.0283f
C403 a_6720_24379# a_14329_19520# 0.0391f
C404 a_20594_19460# a_13305_10622# 0.0448f
C405 a_3181_19520# PB 0.13593f
C406 a_3181_19520# a_11625_10622# 0.69892f
C407 a_5054_1400# VDD 0.34678f
C408 a_7280_5800# a_14660_24080# 0.01404f
C409 a_6720_24379# a_1749_15769# 0.03102f
C410 a_17085_1460# a_13929_20389# 0.29809f
C411 a_25529_24140# a_24944_24080# 0.01041f
C412 a_3374_10220# VDD 0.58329f
C413 PB a_3107_2049# 0.0158f
C414 a_7280_5800# a_8024_5740# 0.0746f
C415 a_3107_2049# a_11625_10622# 2.22281f
C416 a_3374_10220# a_2964_10220# 0.0129f
C417 a_17085_1460# a_3225_1460# 0.05812f
C418 a_25529_24140# VTN 0.66878f
C419 a_4644_1400# a_3225_1460# 0.01202f
C420 a_9178_1400# a_1545_1460# 0.02758f
C421 a_3181_19520# a_5860_19460# 0.02492f
C422 a_1220_14840# VDD 1.95466f
C423 PB BWK 0.04427f
C424 a_13929_20389# a_2169_14900# 0.02548f
C425 BWK a_3060_6082# 0.06961f
C426 a_1427_2049# a_13929_20389# 0.04223f
C427 VDD a_14005_19520# 0.66078f
C428 a_13496_1400# a_1545_1460# 0.02758f
C429 a_15920_19460# a_3181_19520# 0.01194f
R0 BWN BWN.n0 128.226
R1 BWN.n0 BWN.t1 73.3119
R2 BWN.n0 BWN.t2 67.2665
R3 BWN.n0 BWN.t0 15.9366
R4 BWK BWK.n1 102.121
R5 BWK.n0 BWK.t1 73.3119
R6 BWK.n1 BWK.t2 63.1625
R7 BWK.n0 BWK.t0 15.1206
R8 BWK.n1 BWK.n0 4.8965
R9 VTN.t0 VTN.t1 87.2651
R10 VTN VTN.t0 13.7435
R11 a_4760_10280.t2 a_4760_10280.t3 32.1965
R12 a_4760_10280.t3 a_4760_10280.n0 26.9885
R13 a_4760_10280.n0 a_4760_10280.t4 26.4939
R14 a_4760_10280.n0 a_4760_10280.t5 16.4851
R15 a_4760_10280.t1 a_4760_10280.t0 8.86794
R16 a_4760_10280.t0 a_4760_10280.t2 6.1565
R17 a_1400_10280.n3 a_1400_10280.n2 53.8265
R18 a_1400_10280.n2 a_1400_10280.t6 46.0171
R19 a_1400_10280.t3 a_1400_10280.n3 37.6325
R20 a_1400_10280.n0 a_1400_10280.t0 18.4646
R21 a_1400_10280.n3 a_1400_10280.n0 16.5125
R22 a_1400_10280.n1 a_1400_10280.t5 12.7708
R23 a_1400_10280.t1 a_1400_10280.t3 8.65794
R24 a_1400_10280.n0 a_1400_10280.t2 7.45031
R25 a_1400_10280.n1 a_1400_10280.t4 5.2348
R26 a_1400_10280.n2 a_1400_10280.n1 4.8965
R27 a_3080_10280.n25 a_3080_10280.n24 68.1605
R28 a_3080_10280.n23 a_3080_10280.t0 41.6448
R29 a_3080_10280.n12 a_3080_10280.n11 35.6225
R30 a_3080_10280.n7 a_3080_10280.t9 31.9628
R31 a_3080_10280.n8 a_3080_10280.t4 31.9628
R32 a_3080_10280.n4 a_3080_10280.t15 31.9628
R33 a_3080_10280.n5 a_3080_10280.t10 31.9628
R34 a_3080_10280.n1 a_3080_10280.t21 31.9628
R35 a_3080_10280.n2 a_3080_10280.t16 31.9628
R36 a_3080_10280.n11 a_3080_10280.t2 29.7103
R37 a_3080_10280.n24 a_3080_10280.n23 28.1825
R38 a_3080_10280.t22 a_3080_10280.n28 19.6439
R39 a_3080_10280.n20 a_3080_10280.n0 18.3839
R40 a_3080_10280.n10 a_3080_10280.t32 17.9038
R41 a_3080_10280.n10 a_3080_10280.t30 17.9038
R42 a_3080_10280.n15 a_3080_10280.t29 17.9038
R43 a_3080_10280.n15 a_3080_10280.t27 17.9038
R44 a_3080_10280.n18 a_3080_10280.t34 16.6982
R45 a_3080_10280.n17 a_3080_10280.n16 16.1217
R46 a_3080_10280.n26 a_3080_10280.n25 13.4639
R47 a_3080_10280.n14 a_3080_10280.n13 12.5465
R48 a_3080_10280.n9 a_3080_10280.n7 12.3316
R49 a_3080_10280.n9 a_3080_10280.n8 12.3316
R50 a_3080_10280.n6 a_3080_10280.n4 12.3316
R51 a_3080_10280.n6 a_3080_10280.n5 12.3316
R52 a_3080_10280.n3 a_3080_10280.n1 12.3316
R53 a_3080_10280.n3 a_3080_10280.n2 12.3316
R54 a_3080_10280.n0 a_3080_10280.n18 11.8265
R55 a_3080_10280.n24 a_3080_10280.t35 10.8093
R56 a_3080_10280.n14 a_3080_10280.t28 10.4342
R57 a_3080_10280.n18 a_3080_10280.n17 10.2365
R58 a_3080_10280.t23 a_3080_10280.t22 9.6065
R59 a_3080_10280.n13 a_3080_10280.n10 7.59799
R60 a_3080_10280.n11 a_3080_10280.t3 7.45031
R61 a_3080_10280.n7 a_3080_10280.t7 7.3005
R62 a_3080_10280.n8 a_3080_10280.t6 7.3005
R63 a_3080_10280.n4 a_3080_10280.t13 7.3005
R64 a_3080_10280.n5 a_3080_10280.t12 7.3005
R65 a_3080_10280.n1 a_3080_10280.t19 7.3005
R66 a_3080_10280.n2 a_3080_10280.t18 7.3005
R67 a_3080_10280.n23 a_3080_10280.t37 7.10714
R68 a_3080_10280.n25 a_3080_10280.n22 6.1565
R69 a_3080_10280.n12 a_3080_10280.t31 5.93417
R70 a_3080_10280.n0 a_3080_10280.n9 5.54829
R71 a_3080_10280.n16 a_3080_10280.n14 5.36466
R72 a_3080_10280.n28 a_3080_10280.n27 5.1065
R73 a_3080_10280.n22 a_3080_10280.n21 5.1065
R74 a_3080_10280.n0 a_3080_10280.n19 5.1065
R75 a_3080_10280.n28 a_3080_10280.n26 4.5005
R76 a_3080_10280.n22 a_3080_10280.n20 4.5005
R77 a_3080_10280.n13 a_3080_10280.n12 4.5005
R78 a_3080_10280.n17 a_3080_10280.t33 3.94219
R79 a_3080_10280.n21 a_3080_10280.t14 3.4183
R80 a_3080_10280.n27 a_3080_10280.t20 3.4183
R81 a_3080_10280.t25 a_3080_10280.t23 3.4183
R82 a_3080_10280.n19 a_3080_10280.t5 3.36365
R83 a_3080_10280.n19 a_3080_10280.t8 3.0808
R84 a_3080_10280.n21 a_3080_10280.t11 3.02615
R85 a_3080_10280.n27 a_3080_10280.t17 3.02615
R86 a_3080_10280.n16 a_3080_10280.n15 2.23383
R87 a_3080_10280.n20 a_3080_10280.n6 1.20935
R88 a_3080_10280.n26 a_3080_10280.n3 1.20935
R89 a_4905_10280.n1 a_4905_10280.t2 78.1503
R90 a_4905_10280.t0 a_4905_10280.n1 30.5165
R91 a_4905_10280.t1 a_4905_10280.t0 25.3139
R92 a_4905_10280.n0 a_4905_10280.t4 24.1873
R93 a_4905_10280.n0 a_4905_10280.t3 24.1873
R94 a_4905_10280.n1 a_4905_10280.n0 5.98761
R95 a_1545_10280.n1 a_1545_10280.t2 118.37
R96 a_1545_10280.t0 a_1545_10280.n1 25.6865
R97 a_1545_10280.n0 a_1545_10280.t4 25.346
R98 a_1545_10280.n0 a_1545_10280.t3 25.346
R99 a_1545_10280.t1 a_1545_10280.t0 23.6339
R100 a_1545_10280.n1 a_1545_10280.n0 5.94971
R101 a_1749_20389.n3 a_1749_20389.n1 42.7385
R102 a_1749_20389.n2 a_1749_20389.t9 25.346
R103 a_1749_20389.n2 a_1749_20389.t10 25.346
R104 a_1749_20389.n0 a_1749_20389.t3 22.8101
R105 a_1749_20389.n0 a_1749_20389.t1 22.8101
R106 a_1749_20389.t4 a_1749_20389.t0 22.617
R107 a_1749_20389.n1 a_1749_20389.n0 12.289
R108 a_1749_20389.t0 a_1749_20389.n3 12.0125
R109 a_1749_20389.n3 a_1749_20389.n2 10.6487
R110 a_1749_20389.t5 a_1749_20389.t4 9.8165
R111 a_1749_20389.t7 a_1749_20389.t5 5.88144
R112 a_1749_20389.n1 a_1749_20389.t2 5.8714
C430 BWN VSS 27.28533f
C431 BWK VSS 20.76448f
C432 NB VSS 8.08263f
C433 PB VSS 5.09089f
C434 REFCK VSS 18.1165f
C435 VTN VSS 0.11053p
C436 VDD VSS 0.50285p
C437 a_26754_1400# VSS 0.38721f ; **FLOATING
C438 a_26344_1400# VSS 0.38371f ; **FLOATING
C439 a_25074_1400# VSS 0.38449f ; **FLOATING
C440 a_24664_1400# VSS 0.38482f ; **FLOATING
C441 a_23394_1400# VSS 0.38368f ; **FLOATING
C442 a_22984_1400# VSS 0.38482f ; **FLOATING
C443 a_21714_1400# VSS 0.38348f ; **FLOATING
C444 a_21304_1400# VSS 0.38545f ; **FLOATING
C445 a_19678_1400# VSS 1.20227f
C446 a_18580_1400# VSS 1.26181f
C447 a_17234_1400# VSS 0.04368f
C448 a_16824_1400# VSS 0.04368f
C449 a_15554_1400# VSS 0.04368f
C450 a_15144_1400# VSS 0.04368f
C451 a_13496_1400# VSS 1.27346f
C452 a_10880_1400# VSS 1.27346f
C453 a_9178_1400# VSS 1.22315f
C454 a_8080_1400# VSS 1.27346f
C455 a_6734_1400# VSS 0.04368f
C456 a_6324_1400# VSS 0.04368f
C457 a_5054_1400# VSS 0.04368f
C458 a_4644_1400# VSS 0.04368f
C459 a_3374_1400# VSS 0.04368f
C460 a_2964_1400# VSS 0.04368f
C461 a_1694_1400# VSS 0.04368f
C462 a_1284_1400# VSS 0.04368f
C463 a_27314_5740# VSS 0.04368f
C464 a_26904_5740# VSS 0.04368f
C465 a_25634_5740# VSS 0.04368f
C466 a_25224_5740# VSS 0.04368f
C467 a_23954_5740# VSS 0.04368f
C468 a_23544_5740# VSS 0.04368f
C469 a_22274_6082# VSS 0.24097f
C470 a_21864_6082# VSS 0.25096f ; **FLOATING
C471 a_20594_6082# VSS 0.24097f
C472 a_20184_6082# VSS 0.25096f ; **FLOATING
C473 a_18914_6082# VSS 0.24097f
C474 a_18504_6082# VSS 0.25096f ; **FLOATING
C475 a_17234_6082# VSS 0.24097f
C476 a_16824_6082# VSS 0.25096f ; **FLOATING
C477 a_15554_6082# VSS 0.24044f
C478 a_15405_6142# VSS 2.19572f ; **FLOATING
C479 a_15144_6082# VSS 0.25136f ; **FLOATING
C480 a_13874_6082# VSS 0.02717f
C481 a_13725_6142# VSS 1.06603f ; **FLOATING
C482 a_13464_6082# VSS 0.02717f
C483 a_12194_6082# VSS 0.2416f
C484 a_11784_6082# VSS 0.25096f ; **FLOATING
C485 a_11927_6529# VSS 1.5303f ; **FLOATING
C486 a_10404_5740# VSS 0.98252f
C487 a_9400_5740# VSS 0.98252f
C488 a_8024_5740# VSS 0.98252f
C489 a_7020_5740# VSS 0.98252f
C490 a_4958_6082# VSS 1.36509f
C491 a_3060_6082# VSS 1.37015f
C492 a_1694_6082# VSS 0.24044f
C493 a_1545_6142# VSS 5.44854f ; **FLOATING
C494 a_1284_6082# VSS 0.25347f ; **FLOATING
C495 a_26894_10562# VSS 0.24358f
C496 a_26484_10562# VSS 0.25096f ; **FLOATING
C497 a_25214_10562# VSS 0.24232f
C498 a_3225_1460# VSS 7.31522f ; **FLOATING
C499 a_24804_10562# VSS 0.25096f ; **FLOATING
C500 a_23534_10562# VSS 0.24232f
C501 a_23124_10562# VSS 0.25096f ; **FLOATING
C502 a_21854_10562# VSS 0.24232f
C503 a_21444_10562# VSS 0.25096f ; **FLOATING
C504 a_20174_10562# VSS 0.24232f
C505 a_1545_1460# VSS 7.96436f ; **FLOATING
C506 a_19764_10562# VSS 0.25096f ; **FLOATING
C507 a_18494_10562# VSS 0.24232f
C508 a_18084_10562# VSS 0.25096f
C509 a_16814_10562# VSS 0.24044f
C510 a_16665_10622# VSS 4.02906f ; **FLOATING
C511 a_16404_10562# VSS 0.25327f ; **FLOATING
C512 a_15134_10562# VSS 0.24128f
C513 a_14724_10562# VSS 0.25327f ; **FLOATING
C514 a_13454_10562# VSS 0.24044f
C515 a_13044_10562# VSS 0.25327f ; **FLOATING
C516 a_11774_10562# VSS 0.24044f
C517 a_11364_10562# VSS 0.2541f ; **FLOATING
C518 a_9684_10220# VSS 0.14314f
C519 a_8080_10220# VSS 0.14314f
C520 a_6734_10220# VSS 0.07326f
C521 a_6324_10220# VSS 0.07326f
C522 a_5054_10220# VSS 0.07326f
C523 a_4644_10220# VSS 0.07326f
C524 a_3374_10220# VSS 0.07326f
C525 a_2964_10220# VSS 0.07326f
C526 a_1694_10220# VSS 0.07326f
C527 a_1284_10220# VSS 0.07326f
C528 a_26118_14840# VSS 0.14314f
C529 a_25020_14840# VSS 0.14314f
C530 a_23436_14840# VSS 0.14314f
C531 a_20820_14840# VSS 0.14314f
C532 a_19236_14840# VSS 0.14314f
C533 a_16620_14840# VSS 0.14314f
C534 a_15036_14840# VSS 0.14314f
C535 a_12420_14840# VSS 0.14314f
C536 a_10836_14840# VSS 0.14314f
C537 a_8220_14840# VSS 0.14314f
C538 a_6636_14840# VSS 0.14314f
C539 a_4020_14840# VSS 0.14314f
C540 a_2318_14840# VSS 0.14314f
C541 a_2169_14900# VSS 12.8699f ; **FLOATING
C542 a_1220_14840# VSS 0.14314f
C543 a_26398_19460# VSS 0.14314f
C544 a_25300_19460# VSS 0.14314f
C545 a_1749_15769# VSS 10.0196f ; **FLOATING
C546 a_23954_19460# VSS 0.07326f
C547 a_3107_2049# VSS 8.19481f ; **FLOATING
C548 a_23544_19460# VSS 0.07326f
C549 a_1427_2049# VSS 13.0379f ; **FLOATING
C550 a_22274_19460# VSS 0.07326f
C551 a_22125_19520# VSS 0.53536f ; **FLOATING
C552 a_21864_19460# VSS 0.07326f
C553 a_11625_10622# VSS 6.82629f ; **FLOATING
C554 a_20594_19460# VSS 0.07326f
C555 a_13305_10622# VSS 7.05056f ; **FLOATING
C556 a_20184_19460# VSS 0.07326f
C557 a_1427_6529# VSS 12.6773f ; **FLOATING
C558 a_18536_19460# VSS 2.07642f
C559 a_15920_19460# VSS 2.07642f
C560 a_14640_19460# VSS 0.73449f
C561 a_14329_19520# VSS 7.57292f ; **FLOATING
C562 a_14005_19520# VSS 9.57882f ; **FLOATING
C563 a_13744_19460# VSS 0.73611f ; **FLOATING
C564 a_13929_20389# VSS 8.21633f ; **FLOATING
C565 a_12160_19460# VSS 0.14314f
C566 a_7520_19460# VSS 0.14314f
C567 a_5860_19460# VSS 0.14314f
C568 a_1220_19460# VSS 0.14314f
C569 a_27594_24080# VSS 0.07326f
C570 a_20300_19520# VSS 3.40383f ; **FLOATING
C571 a_27184_24080# VSS 0.07326f
C572 a_25840_24080# VSS 0.73789f ; **FLOATING
C573 a_25529_24140# VSS 6.23366f ; **FLOATING
C574 a_25205_24140# VSS 9.63125f ; **FLOATING
C575 a_24944_24080# VSS 0.73449f
C576 a_17085_1460# VSS 11.6393f ; **FLOATING
C577 a_23348_24080# VSS 3.60909f
C578 a_7280_5800# VSS 9.07952f ; **FLOATING
C579 a_14660_24080# VSS 3.60909f
C580 a_13076_24319# VSS 0.21125f
C581 a_10460_24319# VSS 0.21125f
C582 a_8876_24319# VSS 0.21125f
C583 a_7209_24379# VSS 8.365f ; **FLOATING
C584 a_6720_24379# VSS 6.8166f ; **FLOATING
C585 a_6260_24319# VSS 0.21125f
C586 a_27116_32719# VSS 0.94673f
C587 a_16621_24140# VSS 7.28078f ; **FLOATING
C588 a_3181_19520# VSS 16.1533f ; **FLOATING
C589 a_25500_32719# VSS 0.94673f
C590 a_1749_20389.t2 VSS 0.23923f ; **FLOATING
C591 a_1749_20389.t7 VSS 0.33215f ; **FLOATING
C592 a_1749_20389.t3 VSS 0.36541f ; **FLOATING
C593 a_1749_20389.t1 VSS 0.36541f ; **FLOATING
C594 a_1749_20389.n0 VSS 0.54637f ; **FLOATING
C595 a_1749_20389.n1 VSS 1.78512f ; **FLOATING
C596 a_1749_20389.t9 VSS 1.62902f ; **FLOATING
C597 a_1749_20389.t10 VSS 1.62902f ; **FLOATING
C598 a_1749_20389.n2 VSS 1.1732f ; **FLOATING
C599 a_1749_20389.n3 VSS 2.46187f ; **FLOATING
C600 a_1749_20389.t0 VSS 6.27005f ; **FLOATING
C601 a_1749_20389.t4 VSS 11.1486f ; **FLOATING
C602 a_1749_20389.t5 VSS 1.09862f ; **FLOATING
C603 a_1545_10280.t2 VSS 27.2863f ; **FLOATING
C604 a_1545_10280.t3 VSS 0.09229f ; **FLOATING
C605 a_1545_10280.t4 VSS 0.09229f ; **FLOATING
C606 a_1545_10280.n0 VSS 0.06441f ; **FLOATING
C607 a_1545_10280.n1 VSS 0.35237f ; **FLOATING
C608 a_1545_10280.t0 VSS 0.43877f ; **FLOATING
C609 a_1545_10280.t1 VSS 0.03907f ; **FLOATING
C610 a_4905_10280.t2 VSS 24.8057f ; **FLOATING
C611 a_4905_10280.t3 VSS 0.08414f ; **FLOATING
C612 a_4905_10280.t4 VSS 0.08414f ; **FLOATING
C613 a_4905_10280.n0 VSS 0.06357f ; **FLOATING
C614 a_4905_10280.n1 VSS 0.24827f ; **FLOATING
C615 a_4905_10280.t0 VSS 0.30819f ; **FLOATING
C616 a_4905_10280.t1 VSS 0.04091f ; **FLOATING
C617 a_3080_10280.n0 VSS 0.23823f ; **FLOATING
C618 a_3080_10280.t31 VSS 0.055f ; **FLOATING
C619 a_3080_10280.t28 VSS 0.06268f ; **FLOATING
C620 a_3080_10280.t25 VSS 0.08255f ; **FLOATING
C621 a_3080_10280.t20 VSS 0.08255f ; **FLOATING
C622 a_3080_10280.t17 VSS 0.07316f ; **FLOATING
C623 a_3080_10280.t14 VSS 0.08255f ; **FLOATING
C624 a_3080_10280.t11 VSS 0.07316f ; **FLOATING
C625 a_3080_10280.t8 VSS 0.07358f ; **FLOATING
C626 a_3080_10280.t5 VSS 0.08043f ; **FLOATING
C627 a_3080_10280.t19 VSS 0.16364f ; **FLOATING
C628 a_3080_10280.t21 VSS 0.23818f ; **FLOATING
C629 a_3080_10280.n1 VSS 0.11058f ; **FLOATING
C630 a_3080_10280.t18 VSS 0.16364f ; **FLOATING
C631 a_3080_10280.t16 VSS 0.23818f ; **FLOATING
C632 a_3080_10280.n2 VSS 0.11058f ; **FLOATING
C633 a_3080_10280.n3 VSS 0.11064f ; **FLOATING
C634 a_3080_10280.t13 VSS 0.16364f ; **FLOATING
C635 a_3080_10280.t15 VSS 0.23818f ; **FLOATING
C636 a_3080_10280.n4 VSS 0.11058f ; **FLOATING
C637 a_3080_10280.t12 VSS 0.16364f ; **FLOATING
C638 a_3080_10280.t10 VSS 0.23818f ; **FLOATING
C639 a_3080_10280.n5 VSS 0.11058f ; **FLOATING
C640 a_3080_10280.n6 VSS 0.11064f ; **FLOATING
C641 a_3080_10280.t7 VSS 0.16364f ; **FLOATING
C642 a_3080_10280.t9 VSS 0.23818f ; **FLOATING
C643 a_3080_10280.n7 VSS 0.11058f ; **FLOATING
C644 a_3080_10280.t6 VSS 0.16364f ; **FLOATING
C645 a_3080_10280.t4 VSS 0.23818f ; **FLOATING
C646 a_3080_10280.n8 VSS 0.11058f ; **FLOATING
C647 a_3080_10280.n9 VSS 0.18395f ; **FLOATING
C648 a_3080_10280.t32 VSS 0.08115f ; **FLOATING
C649 a_3080_10280.t30 VSS 0.08115f ; **FLOATING
C650 a_3080_10280.n10 VSS 0.10675f ; **FLOATING
C651 a_3080_10280.t2 VSS 0.07521f ; **FLOATING
C652 a_3080_10280.t3 VSS 0.02925f ; **FLOATING
C653 a_3080_10280.n11 VSS 0.38654f ; **FLOATING
C654 a_3080_10280.n12 VSS 0.41068f ; **FLOATING
C655 a_3080_10280.n13 VSS 0.07751f ; **FLOATING
C656 a_3080_10280.n14 VSS 0.07572f ; **FLOATING
C657 a_3080_10280.t29 VSS 0.08115f ; **FLOATING
C658 a_3080_10280.t27 VSS 0.08115f ; **FLOATING
C659 a_3080_10280.n15 VSS 0.07813f ; **FLOATING
C660 a_3080_10280.n16 VSS 0.12011f ; **FLOATING
C661 a_3080_10280.t33 VSS 0.06009f ; **FLOATING
C662 a_3080_10280.n17 VSS 0.13381f ; **FLOATING
C663 a_3080_10280.t34 VSS 0.10299f ; **FLOATING
C664 a_3080_10280.n18 VSS 0.18028f ; **FLOATING
C665 a_3080_10280.n19 VSS 0.15591f ; **FLOATING
C666 a_3080_10280.n20 VSS 0.13643f ; **FLOATING
C667 a_3080_10280.n21 VSS 0.15539f ; **FLOATING
C668 a_3080_10280.n22 VSS 0.02496f ; **FLOATING
C669 a_3080_10280.t37 VSS 41.3478f ; **FLOATING
C670 a_3080_10280.t0 VSS 6.6748f ; **FLOATING
C671 a_3080_10280.n23 VSS 0.77986f ; **FLOATING
C672 a_3080_10280.t35 VSS 6.45556f ; **FLOATING
C673 a_3080_10280.n24 VSS 0.93768f ; **FLOATING
C674 a_3080_10280.n25 VSS 0.71128f ; **FLOATING
C675 a_3080_10280.n26 VSS 0.10977f ; **FLOATING
C676 a_3080_10280.n27 VSS 0.15539f ; **FLOATING
C677 a_3080_10280.n28 VSS 0.11089f ; **FLOATING
C678 a_3080_10280.t22 VSS 1.29458f ; **FLOATING
C679 a_3080_10280.t23 VSS 0.23735f ; **FLOATING
C680 a_1400_10280.t0 VSS 0.0101f ; **FLOATING
C681 a_1400_10280.n0 VSS 0.0319f ; **FLOATING
C682 a_1400_10280.t6 VSS 14.3264f ; **FLOATING
C683 a_1400_10280.t5 VSS 3.804f ; **FLOATING
C684 a_1400_10280.t4 VSS 3.77874f ; **FLOATING
C685 a_1400_10280.n1 VSS 0.06252f ; **FLOATING
C686 a_1400_10280.n2 VSS 0.22723f ; **FLOATING
C687 a_1400_10280.n3 VSS 0.23024f ; **FLOATING
C688 a_1400_10280.t3 VSS 0.12109f ; **FLOATING
C689 a_1400_10280.t1 VSS 0.0162f ; **FLOATING
C690 a_4760_10280.t5 VSS 12.8282f ; **FLOATING
C691 a_4760_10280.t4 VSS 3.45301f ; **FLOATING
C692 a_4760_10280.n0 VSS 0.13033f ; **FLOATING
C693 a_4760_10280.t3 VSS 3.53754f ; **FLOATING
C694 a_4760_10280.t2 VSS 0.08634f ; **FLOATING
C695 a_4760_10280.t0 VSS 0.22467f ; **FLOATING
C696 a_4760_10280.t1 VSS 0.0147f ; **FLOATING
C697 VTN.t1 VSS 16.5284f ; **FLOATING
C698 VTN.t0 VSS 0.81033f ; **FLOATING
C699 BWK.t2 VSS 0.20801f ; **FLOATING
C700 BWK.t1 VSS 0.23942f ; **FLOATING
C701 BWK.t0 VSS 0.1783f ; **FLOATING
C702 BWK.n0 VSS 1.5663f ; **FLOATING
C703 BWK.n1 VSS 8.91273f ; **FLOATING
C704 BWN.n0 VSS 8.67485f ; **FLOATING
C705 BWN.t1 VSS 0.17473f ; **FLOATING
C706 BWN.t0 VSS 0.13012f ; **FLOATING
C707 BWN.t2 VSS 0.19529f ; **FLOATING
.ends
