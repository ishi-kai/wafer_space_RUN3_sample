.subckt mixer_iq RFP RFN L1P L1N L2P L2N L3P L3N L4P L4N NB IFIP IFIN IFQP IFQN VDD VSS
XRT1 vbrf RFP VSS ppolyf_u_1k r_width=1u r_length=5u
XRT2 vbrf RFN VSS ppolyf_u_1k r_width=1u r_length=5u
XRBA vbrf VDD VSS ppolyf_u_1k r_width=1u r_length=20u
XRBB VSS vbrf VSS ppolyf_u_1k r_width=1u r_length=13u
XCBRF vbrf VSS cap_mim_2f0_m4m5_noshield c_width=70e-6 c_length=70e-6 m=1
XRLUA vlou VDD VSS ppolyf_u_1k r_width=1u r_length=47u
XRLUB VSS vlou VSS ppolyf_u_1k r_width=1u r_length=56u
XCLOU vlou VSS cap_mim_2f0_m4m5_noshield c_width=50e-6 c_length=50e-6 m=1
XRLLA vlol VDD VSS ppolyf_u_1k r_width=1u r_length=65u
XRLLB VSS vlol VSS ppolyf_u_1k r_width=1u r_length=37u
XCLOL vlol VSS cap_mim_2f0_m4m5_noshield c_width=50e-6 c_length=50e-6 m=1
XCACL1P gl1p L1P cap_mim_2f0_m4m5_noshield c_width=5e-6 c_length=5e-6 m=40
XRACL1P vlou gl1p VSS ppolyf_u_1k r_width=1u r_length=20u
XCACL1N gl1n L1N cap_mim_2f0_m4m5_noshield c_width=5e-6 c_length=5e-6 m=40
XRACL1N vlou gl1n VSS ppolyf_u_1k r_width=1u r_length=20u
XCACL2P gl2p L2P cap_mim_2f0_m4m5_noshield c_width=5e-6 c_length=5e-6 m=40
XRACL2P vlou gl2p VSS ppolyf_u_1k r_width=1u r_length=20u
XCACL2N gl2n L2N cap_mim_2f0_m4m5_noshield c_width=5e-6 c_length=5e-6 m=40
XRACL2N vlou gl2n VSS ppolyf_u_1k r_width=1u r_length=20u
XCACL3P gl3p L3P cap_mim_2f0_m4m5_noshield c_width=5e-6 c_length=5e-6 m=40
XRACL3P vlol gl3p VSS ppolyf_u_1k r_width=1u r_length=20u
XCACL3N gl3n L3N cap_mim_2f0_m4m5_noshield c_width=5e-6 c_length=5e-6 m=40
XRACL3N vlol gl3n VSS ppolyf_u_1k r_width=1u r_length=20u
XCACL4P gl4p L4P cap_mim_2f0_m4m5_noshield c_width=5e-6 c_length=5e-6 m=40
XRACL4P vlol gl4p VSS ppolyf_u_1k r_width=1u r_length=20u
XCACL4N gl4n L4N cap_mim_2f0_m4m5_noshield c_width=5e-6 c_length=5e-6 m=40
XRACL4N vlol gl4n VSS ppolyf_u_1k r_width=1u r_length=20u
XMCTL1P VSS gl1p VSS VSS nfet_03v3 L=2u W=4.57u nf=1  m=1
XMCTL1N VSS gl1n VSS VSS nfet_03v3 L=2u W=5.66u nf=1  m=1
XMCTL2P VSS gl2p VSS VSS nfet_03v3 L=2u W=3.54u nf=1  m=1
XMCTL2N VSS gl2n VSS VSS nfet_03v3 L=2u W=4.22u nf=1  m=1
XMCTL3P VSS gl3p VSS VSS nfet_03v3 L=2u W=1.55u nf=1  m=1
XMCTL3N VSS gl3n VSS VSS nfet_03v3 L=2u W=0.8u nf=1  m=1
XMCTL4P VSS gl4p VSS VSS nfet_03v3 L=2u W=1.62u nf=1  m=1
XMCTL4N VSS gl4n VSS VSS nfet_03v3 L=2u W=1.57u nf=1  m=1
XMTI tI NB VSS VSS nfet_03v3 L=2u W=40u nf=4  m=16
XMG1I xpI RFP tI VSS nfet_03v3 L=0.28u W=80u nf=16  m=1
XMG2I xnI RFN tI VSS nfet_03v3 L=0.28u W=80u nf=16  m=1
XMLApI mpaI gl3n xpI VSS nfet_03v3 L=0.28u W=40u nf=8  m=1
XMLBpI mpbI gl3p xpI VSS nfet_03v3 L=0.28u W=40u nf=8  m=1
XMU1pI IFIP gl1p mpaI VSS nfet_03v3 L=0.28u W=20u nf=4  m=1
XMU2pI IFIN gl1n mpaI VSS nfet_03v3 L=0.28u W=20u nf=4  m=1
XMU3pI IFIN gl1p mpbI VSS nfet_03v3 L=0.28u W=20u nf=4  m=1
XMU4pI IFIP gl1n mpbI VSS nfet_03v3 L=0.28u W=20u nf=4  m=1
XMLAnI mnaI gl3n xnI VSS nfet_03v3 L=0.28u W=40u nf=8  m=1
XMLBnI mnbI gl3p xnI VSS nfet_03v3 L=0.28u W=40u nf=8  m=1
XMU1nI IFIN gl1p mnaI VSS nfet_03v3 L=0.28u W=20u nf=4  m=1
XMU2nI IFIP gl1n mnaI VSS nfet_03v3 L=0.28u W=20u nf=4  m=1
XMU3nI IFIP gl1p mnbI VSS nfet_03v3 L=0.28u W=20u nf=4  m=1
XMU4nI IFIN gl1n mnbI VSS nfet_03v3 L=0.28u W=20u nf=4  m=1
XRL1I IFIP VDD VSS ppolyf_u_1k r_width=4u r_length=5u
XRL2I IFIN VDD VSS ppolyf_u_1k r_width=4u r_length=5u
XCL1I IFIP VSS cap_mim_2f0_m4m5_noshield c_width=46.98e-6 c_length=46.98e-6 m=1
XCL2I IFIN VSS cap_mim_2f0_m4m5_noshield c_width=46.98e-6 c_length=46.98e-6 m=1
XMTQ tQ NB VSS VSS nfet_03v3 L=2u W=40u nf=4  m=16
XMG1Q xpQ RFP tQ VSS nfet_03v3 L=0.28u W=80u nf=16  m=1
XMG2Q xnQ RFN tQ VSS nfet_03v3 L=0.28u W=80u nf=16  m=1
XMLApQ mpaQ gl4n xpQ VSS nfet_03v3 L=0.28u W=40u nf=8  m=1
XMLBpQ mpbQ gl4p xpQ VSS nfet_03v3 L=0.28u W=40u nf=8  m=1
XMU1pQ IFQP gl2p mpaQ VSS nfet_03v3 L=0.28u W=20u nf=4  m=1
XMU2pQ IFQN gl2n mpaQ VSS nfet_03v3 L=0.28u W=20u nf=4  m=1
XMU3pQ IFQN gl2p mpbQ VSS nfet_03v3 L=0.28u W=20u nf=4  m=1
XMU4pQ IFQP gl2n mpbQ VSS nfet_03v3 L=0.28u W=20u nf=4  m=1
XMLAnQ mnaQ gl4n xnQ VSS nfet_03v3 L=0.28u W=40u nf=8  m=1
XMLBnQ mnbQ gl4p xnQ VSS nfet_03v3 L=0.28u W=40u nf=8  m=1
XMU1nQ IFQN gl2p mnaQ VSS nfet_03v3 L=0.28u W=20u nf=4  m=1
XMU2nQ IFQP gl2n mnaQ VSS nfet_03v3 L=0.28u W=20u nf=4  m=1
XMU3nQ IFQP gl2p mnbQ VSS nfet_03v3 L=0.28u W=20u nf=4  m=1
XMU4nQ IFQN gl2n mnbQ VSS nfet_03v3 L=0.28u W=20u nf=4  m=1
XRL1Q IFQP VDD VSS ppolyf_u_1k r_width=4u r_length=5u
XRL2Q IFQN VDD VSS ppolyf_u_1k r_width=4u r_length=5u
XCL1Q IFQP VSS cap_mim_2f0_m4m5_noshield c_width=46.98e-6 c_length=46.98e-6 m=1
XCL2Q IFQN VSS cap_mim_2f0_m4m5_noshield c_width=46.98e-6 c_length=46.98e-6 m=1
.ends
