.subckt lna_nc RFIN PB OUTP OUTN VDD VSS
XM1 op_i vb1 RFIN VSS nfet_03v3 L=0.28u W=40u nf=8  m=3
XRS VSS RFIN VSS ppolyf_u_1k r_width=10u r_length=3u
XR1 op_i VDD VSS ppolyf_u_1k r_width=10u r_length=2u
XCC2 g2 RFIN cap_mim_2f0_m4m5_noshield c_width=5e-6 c_length=5e-6 m=81
XRB2 vb2 g2 VSS ppolyf_u_1k r_width=1u r_length=10u
XM2 on_i g2 VSS VSS nfet_03v3 L=0.28u W=40u nf=8  m=8
XR2 on_i VDD VSS ppolyf_u_1k r_width=30u r_length=2.17u
XMP1 vb1 PB VDD VDD pfet_03v3 L=2u W=32u nf=4  m=6
XM1R vb1 vb1 s1r VSS nfet_03v3 L=0.28u W=12u nf=2  m=1
XRSR VSS s1r VSS ppolyf_u_1k r_width=1u r_length=3u
XMP2 vb2 PB VDD VDD pfet_03v3 L=2u W=32u nf=4  m=5
XM2R vb2 vb2 VSS VSS nfet_03v3 L=0.28u W=8u nf=2  m=1
XCB1 vb1 VSS cap_mim_2f0_m4m5_noshield c_width=50e-6 c_length=50e-6 m=1
XCB2 vb2 VSS cap_mim_2f0_m4m5_noshield c_width=50e-6 c_length=50e-6 m=1
XCOP OUTP op_i cap_mim_2f0_m4m5_noshield c_width=5e-6 c_length=5e-6 m=81
XCON OUTN on_i cap_mim_2f0_m4m5_noshield c_width=5e-6 c_length=5e-6 m=81
.ends
