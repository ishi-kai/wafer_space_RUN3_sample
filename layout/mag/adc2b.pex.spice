* NGSPICE file created from adc2b_flat.ext - technology: gf180mcuD

.subckt adc2b_flat VSS VDD INP INN CLK SIGN MAG
X0 a_8847_25989# INN cap_mim_2f0_m4m5_noshield c_width=52.2u c_length=52.2u
X1 a_3785_25120# a_5347_25989# a_3640_25120# VSS nfet_03v3 ad=1.78p pd=8.89u as=1.78p ps=8.89u w=4u l=0.28u
X2 a_45780_29740# CLK.t5 VDD VDD pfet_03v3 ad=0.445p pd=2.89u as=0.445p ps=2.89u w=1u l=0.28u
X3 a_5347_25989# INP cap_mim_2f0_m4m5_noshield c_width=52.2u c_length=52.2u
X4 a_22567_39429# CLK.t12 VDD VDD pfet_03v3 ad=0.445p pd=2.89u as=0.445p ps=2.89u w=1u l=0.28u
X5 a_7980_29740# a_1720_1644# a_3640_25120# VSS nfet_03v3 ad=1.78p pd=8.89u as=1.78p ps=8.89u w=4u l=0.28u
X6 a_11740_3370# a_13980_1644# VSS ppolyf_u_1k r_width=10u r_length=8.02u
X7 a_49140_43180# a_45925_38700# VDD VDD pfet_03v3 ad=1.78p pd=8.89u as=1.78p ps=8.89u w=4u l=0.28u
X8 a_8125_38700# a_5347_30329# VSS VSS nfet_03v3 ad=0.445p pd=2.89u as=0.445p ps=2.89u w=1u l=0.28u
X9 a_41585_25120# a_11740_1644# a_41440_25120# VSS nfet_03v3 ad=1.78p pd=8.89u as=1.78p ps=8.89u w=4u l=0.28u
X10 a_22685_43522# a_24247_43909# a_26045_43180# VDD pfet_03v3 ad=1.78p pd=8.89u as=1.78p ps=8.89u w=4u l=0.28u
X11 a_22685_25120# CLK.t8 VDD VDD pfet_03v3 ad=0.445p pd=2.89u as=0.445p ps=2.89u w=1u l=0.28u
X12 a_27025_38700# a_24247_30329# VDD VDD pfet_03v3 ad=0.89p pd=4.89u as=0.89p ps=4.89u w=2u l=0.28u
X13 a_8440_3766# a_7600_1644# VSS ppolyf_u_1k r_width=1u r_length=10u
X14 VSS CLK.t0 a_41440_25120# VSS nfet_03v3 ad=1.78p pd=8.89u as=1.06p ps=4.53u w=4u l=0.28u
X15 a_5347_30329# CLK.t4 VDD VDD pfet_03v3 ad=0.445p pd=2.89u as=0.445p ps=2.89u w=1u l=0.28u
X16 a_26880_29740# a_11740_1644# a_22540_25120# VSS nfet_03v3 ad=1.78p pd=8.89u as=1.78p ps=8.89u w=4u l=0.28u
X17 a_43147_30329# a_41467_39429# a_45780_29740# VSS nfet_03v3 ad=0.89p pd=4.89u as=0.89p ps=4.89u w=2u l=0.28u
X18 a_22567_43909# a_22567_39429# VDD VDD pfet_03v3 ad=0.89p pd=4.89u as=0.89p ps=4.89u w=2u l=0.28u
X19 a_3785_43522# a_3667_43909# VSS VSS nfet_03v3 ad=0.445p pd=2.89u as=0.445p ps=2.89u w=1u l=0.28u
X20 a_22685_43522# a_24247_43909# VSS VSS nfet_03v3 ad=0.445p pd=2.89u as=0.445p ps=2.89u w=1u l=0.28u
X21 a_5080_3766# a_4240_1644# VSS ppolyf_u_1k r_width=1u r_length=10u
X22 a_24247_43909# a_22685_43522# VSS VSS nfet_03v3 ad=0.445p pd=2.89u as=0.445p ps=2.89u w=1u l=0.28u
X23 a_24247_30329# a_22567_39429# VDD VDD pfet_03v3 ad=0.89p pd=4.89u as=0.89p ps=4.89u w=2u l=0.28u
X24 VDD a_18460_1644# VSS ppolyf_u_1k r_width=10u r_length=8.02u
X25 SIGN a_3785_43522# a_11340_43180# VDD pfet_03v3 ad=1.78p pd=8.89u as=1.78p ps=8.89u w=4u l=0.28u
X26 a_3820_3766# a_2980_1644# VSS ppolyf_u_1k r_width=1u r_length=10u
X27 a_7980_29740# CLK.t4 VDD VDD pfet_03v3 ad=0.445p pd=2.89u as=0.445p ps=2.89u w=1u l=0.28u
X28 a_41467_39429# a_43147_30329# a_41585_25120# VSS nfet_03v3 ad=0.89p pd=4.89u as=0.89p ps=4.89u w=2u l=0.28u
X29 a_22567_39429# a_24247_30329# VDD VDD pfet_03v3 ad=0.89p pd=4.89u as=0.89p ps=4.89u w=2u l=0.28u
X30 a_5347_30329# a_3667_39429# a_7980_29740# VSS nfet_03v3 ad=0.89p pd=4.89u as=0.89p ps=4.89u w=2u l=0.28u
X31 a_2140_3766# a_2980_1644# VSS ppolyf_u_1k r_width=1u r_length=10u
X32 a_16220_3370# a_13980_1644# VSS ppolyf_u_1k r_width=10u r_length=8.02u
X33 a_45780_29740# a_8847_25989# a_41440_25120# VSS nfet_03v3 ad=1.78p pd=8.89u as=1.78p ps=8.89u w=4u l=0.28u
X34 a_3785_25120# a_1720_1644# a_3640_25120# VSS nfet_03v3 ad=1.78p pd=8.89u as=1.78p ps=8.89u w=4u l=0.28u
X35 a_22685_25120# a_5347_25989# a_22540_25120# VSS nfet_03v3 ad=1.78p pd=8.89u as=1.78p ps=8.89u w=4u l=0.28u
X36 a_41440_25120# CLK.t1 VSS VSS nfet_03v3 ad=1.06p pd=4.53u as=1.78p ps=8.89u w=4u l=0.28u
X37 a_8440_3766# a_5347_25989# VSS ppolyf_u_1k r_width=1u r_length=10u
X38 VSS CLK.t4 a_3640_25120# VSS nfet_03v3 ad=1.78p pd=8.89u as=1.06p ps=4.53u w=4u l=0.28u
X39 a_11740_1644# a_1720_1644# VSS ppolyf_u_1k r_width=10u r_length=1.4u
X40 a_5500_3766# a_4660_1644# VSS ppolyf_u_1k r_width=1u r_length=10u
X41 SIGN a_8125_38700# VSS VSS nfet_03v3 ad=0.445p pd=2.89u as=0.445p ps=2.89u w=1u l=0.28u
X42 a_27025_38700# a_24247_30329# VSS VSS nfet_03v3 ad=0.445p pd=2.89u as=0.445p ps=2.89u w=1u l=0.28u
X43 a_3640_25120# CLK.t4 VSS VSS nfet_03v3 ad=1.06p pd=4.53u as=1.78p ps=8.89u w=4u l=0.28u
X44 a_3820_3766# a_4660_1644# VSS ppolyf_u_1k r_width=1u r_length=10u
X45 a_2140_3766# a_1720_1644# VSS ppolyf_u_1k r_width=1u r_length=10u
X46 a_26045_43180# a_22567_43909# VDD VDD pfet_03v3 ad=1.78p pd=8.89u as=1.78p ps=8.89u w=4u l=0.28u
X47 a_3667_39429# a_5347_30329# a_3785_25120# VSS nfet_03v3 ad=0.89p pd=4.89u as=0.89p ps=4.89u w=2u l=0.28u
X48 MAG a_43147_43909# VDD VDD pfet_03v3 ad=0.89p pd=4.89u as=0.89p ps=4.89u w=2u l=0.28u
X49 a_16220_3370# a_18460_1644# VSS ppolyf_u_1k r_width=10u r_length=8.02u
X50 a_43147_43909# a_45925_38700# VSS VSS nfet_03v3 ad=0.445p pd=2.89u as=0.445p ps=2.89u w=1u l=0.28u
X51 a_24247_30329# CLK.t11 VDD VDD pfet_03v3 ad=0.445p pd=2.89u as=0.445p ps=2.89u w=1u l=0.28u
X52 a_30240_43180# a_27025_38700# VDD VDD pfet_03v3 ad=1.78p pd=8.89u as=1.78p ps=8.89u w=4u l=0.28u
X53 a_22685_43522# a_22567_43909# VSS VSS nfet_03v3 ad=0.445p pd=2.89u as=0.445p ps=2.89u w=1u l=0.28u
X54 a_7980_29740# a_8847_25989# a_3640_25120# VSS nfet_03v3 ad=1.78p pd=8.89u as=1.78p ps=8.89u w=4u l=0.28u
X55 a_8860_3766# a_8847_25989# VSS ppolyf_u_1k r_width=1u r_length=10u
X56 a_26880_29740# CLK.t7 VDD VDD pfet_03v3 ad=0.445p pd=2.89u as=0.445p ps=2.89u w=1u l=0.28u
X57 a_41467_43909# a_41467_39429# VSS VSS nfet_03v3 ad=0.445p pd=2.89u as=0.445p ps=2.89u w=1u l=0.28u
X58 a_58100_22740# a_43147_43909# VSS VSS nfet_03v3 ad=0.89p pd=4.89u as=0.89p ps=4.89u w=2u l=0.28u
X59 a_5500_3766# a_6340_1644# VSS ppolyf_u_1k r_width=1u r_length=10u
X60 a_8860_3766# a_8020_1644# VSS ppolyf_u_1k r_width=1u r_length=10u
X61 a_41467_39429# CLK.t10 VDD VDD pfet_03v3 ad=0.445p pd=2.89u as=0.445p ps=2.89u w=1u l=0.28u
X62 a_22685_25120# a_22567_25989# a_22540_25120# VSS nfet_03v3 ad=1.78p pd=8.89u as=1.78p ps=8.89u w=4u l=0.28u
X63 a_22567_25989# a_29660_1644# VSS ppolyf_u_1k r_width=10u r_length=7.435u
X64 VSS CLK.t2 a_22540_25120# VSS nfet_03v3 ad=1.78p pd=8.89u as=1.06p ps=4.53u w=4u l=0.28u
X65 a_1720_3766# a_1720_1644# VSS ppolyf_u_1k r_width=1u r_length=10u
X66 a_45925_38700# a_43147_30329# VDD VDD pfet_03v3 ad=0.89p pd=4.89u as=0.89p ps=4.89u w=2u l=0.28u
X67 a_41585_43522# a_43147_43909# a_44945_43180# VDD pfet_03v3 ad=1.78p pd=8.89u as=1.78p ps=8.89u w=4u l=0.28u
X68 a_41585_25120# CLK.t6 VDD VDD pfet_03v3 ad=0.445p pd=2.89u as=0.445p ps=2.89u w=1u l=0.28u
X69 a_24247_30329# a_22567_39429# a_26880_29740# VSS nfet_03v3 ad=0.89p pd=4.89u as=0.89p ps=4.89u w=2u l=0.28u
X70 SIGN a_3785_43522# VSS VSS nfet_03v3 ad=0.445p pd=2.89u as=0.445p ps=2.89u w=1u l=0.28u
X71 a_45780_29740# a_22567_25989# a_41440_25120# VSS nfet_03v3 ad=1.78p pd=8.89u as=1.78p ps=8.89u w=4u l=0.28u
X72 a_27420_3253# VSS VSS ppolyf_u_1k r_width=10u r_length=7.435u
X73 a_41467_43909# a_41467_39429# VDD VDD pfet_03v3 ad=0.89p pd=4.89u as=0.89p ps=4.89u w=2u l=0.28u
X74 a_41585_43522# a_43147_43909# VSS VSS nfet_03v3 ad=0.445p pd=2.89u as=0.445p ps=2.89u w=1u l=0.28u
X75 a_7180_3766# a_8020_1644# VSS ppolyf_u_1k r_width=1u r_length=10u
X76 MAG a_22685_43522# VDD VDD pfet_03v3 ad=0.89p pd=4.89u as=0.89p ps=4.89u w=2u l=0.28u
X77 a_22567_39429# a_24247_30329# a_22685_25120# VSS nfet_03v3 ad=0.89p pd=4.89u as=0.89p ps=4.89u w=2u l=0.28u
X78 MAG a_22685_43522# a_58100_22740# VSS nfet_03v3 ad=0.89p pd=4.89u as=0.89p ps=4.89u w=2u l=0.28u
X79 a_43147_43909# a_41585_43522# VSS VSS nfet_03v3 ad=0.445p pd=2.89u as=0.445p ps=2.89u w=1u l=0.28u
X80 a_43147_30329# a_41467_39429# VDD VDD pfet_03v3 ad=0.89p pd=4.89u as=0.89p ps=4.89u w=2u l=0.28u
X81 a_8125_38700# a_5347_30329# VDD VDD pfet_03v3 ad=0.89p pd=4.89u as=0.89p ps=4.89u w=2u l=0.28u
X82 a_3667_43909# a_3667_39429# VSS VSS nfet_03v3 ad=0.445p pd=2.89u as=0.445p ps=2.89u w=1u l=0.28u
X83 a_24247_43909# a_22685_43522# a_30240_43180# VDD pfet_03v3 ad=1.78p pd=8.89u as=1.78p ps=8.89u w=4u l=0.28u
X84 a_7180_3766# a_6340_1644# VSS ppolyf_u_1k r_width=1u r_length=10u
X85 a_41467_39429# a_43147_30329# VDD VDD pfet_03v3 ad=0.89p pd=4.89u as=0.89p ps=4.89u w=2u l=0.28u
X86 a_3667_39429# CLK.t4 VDD VDD pfet_03v3 ad=0.445p pd=2.89u as=0.445p ps=2.89u w=1u l=0.28u
X87 a_3400_3766# a_2560_1644# VSS ppolyf_u_1k r_width=1u r_length=10u
X88 a_11740_1644# VSS cap_mim_2f0_m4m5_noshield c_width=50u c_length=50u
X89 a_5080_3766# a_5920_1644# VSS ppolyf_u_1k r_width=1u r_length=10u
X90 a_26880_29740# a_8847_25989# a_22540_25120# VSS nfet_03v3 ad=1.78p pd=8.89u as=1.78p ps=8.89u w=4u l=0.28u
X91 a_22540_25120# CLK.t3 VSS VSS nfet_03v3 ad=1.06p pd=4.53u as=1.78p ps=8.89u w=4u l=0.28u
X92 a_5347_30329# a_3667_39429# VDD VDD pfet_03v3 ad=0.89p pd=4.89u as=0.89p ps=4.89u w=2u l=0.28u
X93 a_1720_1644# a_22567_25989# VSS ppolyf_u_1k r_width=10u r_length=1.4u
X94 a_43147_43909# a_41585_43522# a_49140_43180# VDD pfet_03v3 ad=1.78p pd=8.89u as=1.78p ps=8.89u w=4u l=0.28u
X95 a_41585_25120# a_5347_25989# a_41440_25120# VSS nfet_03v3 ad=1.78p pd=8.89u as=1.78p ps=8.89u w=4u l=0.28u
X96 a_3785_43522# SIGN a_7145_43180# VDD pfet_03v3 ad=1.78p pd=8.89u as=1.78p ps=8.89u w=4u l=0.28u
X97 a_27420_3253# a_29660_1644# VSS ppolyf_u_1k r_width=10u r_length=7.435u
X98 a_1720_3766# a_2560_1644# VSS ppolyf_u_1k r_width=1u r_length=10u
X99 a_3785_25120# CLK.t4 VDD VDD pfet_03v3 ad=0.445p pd=2.89u as=0.445p ps=2.89u w=1u l=0.28u
X100 a_1720_1644# VSS cap_mim_2f0_m4m5_noshield c_width=50u c_length=50u
X101 a_3667_43909# a_3667_39429# VDD VDD pfet_03v3 ad=0.89p pd=4.89u as=0.89p ps=4.89u w=2u l=0.28u
X102 a_3785_43522# SIGN VSS VSS nfet_03v3 ad=0.445p pd=2.89u as=0.445p ps=2.89u w=1u l=0.28u
X103 a_24247_43909# a_27025_38700# VSS VSS nfet_03v3 ad=0.445p pd=2.89u as=0.445p ps=2.89u w=1u l=0.28u
X104 a_22567_25989# VSS cap_mim_2f0_m4m5_noshield c_width=50u c_length=50u
X105 a_45925_38700# a_43147_30329# VSS VSS nfet_03v3 ad=0.445p pd=2.89u as=0.445p ps=2.89u w=1u l=0.28u
X106 a_11340_43180# a_8125_38700# VDD VDD pfet_03v3 ad=1.78p pd=8.89u as=1.78p ps=8.89u w=4u l=0.28u
X107 a_44945_43180# a_41467_43909# VDD VDD pfet_03v3 ad=1.78p pd=8.89u as=1.78p ps=8.89u w=4u l=0.28u
X108 a_6760_3766# a_7600_1644# VSS ppolyf_u_1k r_width=1u r_length=10u
X109 a_11740_3370# a_11740_1644# VSS ppolyf_u_1k r_width=10u r_length=8.02u
X110 a_43147_30329# CLK.t9 VDD VDD pfet_03v3 ad=0.445p pd=2.89u as=0.445p ps=2.89u w=1u l=0.28u
X111 a_3667_39429# a_5347_30329# VDD VDD pfet_03v3 ad=0.89p pd=4.89u as=0.89p ps=4.89u w=2u l=0.28u
X112 a_3400_3766# a_4240_1644# VSS ppolyf_u_1k r_width=1u r_length=10u
X113 a_6760_3766# a_5920_1644# VSS ppolyf_u_1k r_width=1u r_length=10u
X114 a_41585_43522# a_41467_43909# VSS VSS nfet_03v3 ad=0.445p pd=2.89u as=0.445p ps=2.89u w=1u l=0.28u
X115 a_7145_43180# a_3667_43909# VDD VDD pfet_03v3 ad=1.78p pd=8.89u as=1.78p ps=8.89u w=4u l=0.28u
X116 a_22567_43909# a_22567_39429# VSS VSS nfet_03v3 ad=0.445p pd=2.89u as=0.445p ps=2.89u w=1u l=0.28u
C0 a_24247_30329# a_11740_1644# 1.01336f
C1 a_46364_43120# VDD 0.58253f
C2 a_24247_43909# a_11740_1644# 0.04359f
C3 a_22567_39429# a_22567_43909# 0.11878f
C4 a_3667_39429# a_5347_30329# 0.62414f
C5 CLK a_41440_25120# 0.13738f
C6 a_45094_43120# a_44684_43120# 0.0129f
C7 a_50704_43120# VDD 0.63223f
C8 a_8974_43120# a_3785_43522# 0.04484f
C9 CLK a_11740_1644# 0.31414f
C10 a_49434_43120# VDD 0.58329f
C11 a_41585_43522# a_46774_43120# 0.04484f
C12 a_24247_30329# a_27025_38700# 0.14279f
C13 a_3785_43522# a_5614_43462# 0.01595f
C14 SIGN a_11740_1644# 0.04359f
C15 a_24247_43909# a_27025_38700# 0.10869f
C16 a_11740_1644# VDD 3.7773f
C17 a_44684_43120# VDD 0.63479f
C18 a_4660_1644# a_4240_1644# 0.1684f
C19 CLK a_8125_38700# 0.04359f
C20 a_30534_43120# a_30124_43120# 0.0129f
C21 CLK a_27025_38700# 0.04359f
C22 a_8125_38700# SIGN 0.10869f
C23 a_8125_38700# VDD 1.39801f
C24 a_45925_38700# a_49140_43180# 0.06318f
C25 SIGN a_16674_43462# 0.01296f
C26 a_5080_3766# a_3820_3766# 0.01209f
C27 VDD a_27025_38700# 1.39801f
C28 a_3667_39429# a_5614_38640# 0.01094f
C29 a_30240_43180# a_32214_43120# 0.04066f
C30 a_7145_43180# a_7294_43120# 0.04654f
C31 a_26045_43180# a_22685_43522# 0.37231f
C32 VDD a_7294_43120# 0.60019f
C33 a_24247_30329# a_22567_25989# 0.03924f
C34 CLK a_22540_25120# 0.13796f
C35 a_24247_43909# a_22567_25989# 0.04359f
C36 a_11634_43120# a_11340_43180# 0.01648f
C37 a_43414_38640# VDD 0.34967f
C38 a_43147_43909# a_44945_43180# 0.20754f
C39 a_4240_1644# a_2980_1644# 0.01209f
C40 a_18460_1644# a_11740_1644# 0.02213f
C41 a_26045_43180# a_22567_43909# 0.05138f
C42 CLK a_22567_25989# 0.39335f
C43 a_24247_30329# a_8847_25989# 0.65417f
C44 a_24247_43909# a_8847_25989# 0.01409f
C45 a_8564_43120# a_7145_43180# 0.04961f
C46 SIGN a_22567_25989# 0.04359f
C47 a_3785_43522# a_3934_43462# 0.01511f
C48 VDD a_22567_25989# 2.93934f
C49 SIGN a_8564_43120# 0.01306f
C50 a_8564_43120# VDD 0.58253f
C51 a_8274_34160# a_5347_30329# 0.02223f
C52 a_8847_25989# INP 0.01002f
C53 INN a_8847_25989# 7.75634f
C54 a_27874_43120# a_22685_43522# 0.04484f
C55 a_3820_3766# a_3400_3766# 0.1684f
C56 a_11740_1644# a_13980_1644# 0.03271f
C57 CLK a_8847_25989# 5.01402f
C58 a_11634_43120# a_11224_43120# 0.0129f
C59 a_43147_43909# a_22685_43522# 0.39629f
C60 a_8125_38700# a_9954_38982# 0.0139f
C61 a_41467_39429# CLK 0.16378f
C62 SIGN a_8847_25989# 0.5008f
C63 a_8847_25989# VDD 3.70156f
C64 a_2560_1644# a_2980_1644# 0.1684f
C65 a_41467_39429# VDD 3.16979f
C66 a_45925_38700# a_47754_38982# 0.0139f
C67 a_27174_38640# a_27025_38700# 0.02481f
C68 a_43147_43909# a_41585_43522# 0.69483f
C69 INP a_5347_25989# 7.57022f
C70 INN a_5347_25989# 0.38864f
C71 a_30534_43120# a_24247_43909# 0.04353f
C72 CLK a_5347_25989# 0.18052f
C73 a_3640_25120# CLK 0.13796f
C74 INP a_1720_1644# 0.83188f
C75 INN a_1720_1644# 0.03406f
C76 CLK a_1720_1644# 0.13794f
C77 CLK a_3667_43909# 0.07707f
C78 SIGN a_5347_25989# 0.06075f
C79 VDD a_5347_25989# 4.8231f
C80 SIGN a_11634_43120# 0.04353f
C81 a_22567_25989# a_27420_3253# 0.11383f
C82 CLK a_45780_29740# 0.08625f
C83 a_11634_43120# VDD 0.58329f
C84 a_7145_43180# a_3667_43909# 0.05138f
C85 SIGN a_3667_43909# 0.11516f
C86 a_3400_3766# a_2140_3766# 0.01209f
C87 a_30124_43120# a_22685_43522# 0.01581f
C88 VDD a_3667_43909# 1.29151f
C89 VDD a_1720_1644# 2.35054f
C90 a_47344_30022# VDD 0.22431f
C91 a_43147_43909# a_46774_43120# 0.01283f
C92 a_47754_30022# VDD 0.21693f
C93 VDD a_45780_29740# 0.79156f
C94 a_24247_30329# a_27174_29680# 0.01993f
C95 a_8125_38700# a_5347_30329# 0.14279f
C96 a_30534_43120# VDD 0.58329f
C97 a_24247_30329# a_26880_29740# 0.20813f
C98 CLK a_41585_25120# 0.02299f
C99 a_41734_30022# VDD 0.21379f
C100 VDD a_41585_25120# 0.76583f
C101 a_41324_30022# VDD 0.22745f
C102 a_24247_30329# a_26764_29680# 0.0137f
C103 a_28854_30022# VDD 0.21617f
C104 a_28444_30022# VDD 0.22418f
C105 CLK a_26880_29740# 0.08117f
C106 a_1720_3766# a_2140_3766# 0.1684f
C107 a_3934_38982# a_3667_43909# 0.01732f
C108 a_41585_43522# a_49024_43120# 0.01581f
C109 a_49140_43180# a_50704_43120# 0.01509f
C110 a_26880_29740# VDD 0.77957f
C111 a_24247_30329# a_22685_25120# 0.02337f
C112 a_49434_43120# a_49140_43180# 0.01648f
C113 a_18460_1644# a_1720_1644# 0.12495f
C114 VDD a_6884_43120# 0.63479f
C115 CLK a_22685_25120# 0.0187f
C116 a_45094_43120# a_44945_43180# 0.04654f
C117 a_22834_30022# VDD 0.21366f
C118 VDD a_22685_25120# 0.75629f
C119 a_5347_30329# a_8847_25989# 0.65417f
C120 a_7864_38640# VDD 0.36665f
C121 a_22424_30022# VDD 0.22669f
C122 VDD a_9954_30022# 0.21617f
C123 a_13980_1644# a_1720_1644# 0.11447f
C124 a_8847_25989# a_10100_1644# 0.03012f
C125 a_9544_30022# VDD 0.22418f
C126 a_24247_30329# a_26764_34160# 0.01146f
C127 a_44945_43180# VDD 0.88551f
C128 CLK a_7980_29740# 0.08117f
C129 a_24247_43909# a_22685_43522# 0.69522f
C130 VDD a_7980_29740# 0.77957f
C131 a_8125_38700# a_3785_43522# 0.38327f
C132 MAG a_22685_43522# 0.28356f
C133 CLK a_22685_43522# 0.03851f
C134 a_5347_30329# a_1720_1644# 0.75417f
C135 a_24247_43909# a_22567_43909# 0.11516f
C136 a_26764_34160# VDD 0.3627f
C137 a_24247_30329# a_22567_39429# 0.58617f
C138 a_22567_39429# a_22834_34502# 0.01226f
C139 CLK a_3785_25120# 0.0187f
C140 VDD a_22685_43522# 2.36135f
C141 CLK a_43147_30329# 0.12136f
C142 a_8860_3766# a_5347_25989# 0.04712f
C143 VDD a_3934_30022# 0.21366f
C144 VDD a_43147_30329# 3.2999f
C145 VDD a_3785_25120# 0.75629f
C146 a_60074_22680# a_58100_22740# 0.01988f
C147 a_8440_3766# a_5347_25989# 0.01185f
C148 VDD a_47754_34502# 0.21693f
C149 a_8564_43120# a_8974_43120# 0.0129f
C150 VDD a_3524_30022# 0.22669f
C151 VDD a_46074_34160# 0.35048f
C152 CLK a_22567_43909# 0.07707f
C153 a_8020_1644# a_5347_25989# 0.01868f
C154 a_47344_34502# VDD 0.22431f
C155 a_24247_30329# a_28854_34502# 0.01149f
C156 CLK a_22567_39429# 0.15489f
C157 a_41585_43522# VDD 1.74814f
C158 a_8020_1644# a_1720_1644# 0.04705f
C159 a_26194_43120# a_25784_43120# 0.0129f
C160 a_22567_43909# VDD 1.29151f
C161 a_8274_38640# a_8125_38700# 0.02481f
C162 a_7600_1644# a_1720_1644# 0.01858f
C163 a_45664_34160# VDD 0.36279f
C164 a_22567_39429# VDD 3.12607f
C165 VDD a_43414_34160# 0.3476f
C166 VDD a_3524_34502# 0.22745f
C167 a_57984_22680# a_58100_22740# 0.01998f
C168 a_8564_43120# a_3785_43522# 0.01772f
C169 a_41734_34502# VDD 0.21462f
C170 VDD a_43004_34160# 0.36665f
C171 a_6340_1644# a_1720_1644# 0.04778f
C172 a_5920_1644# a_1720_1644# 0.01858f
C173 VDD a_46074_38640# 0.3476f
C174 VDD a_41324_34502# 0.22745f
C175 a_30240_43180# a_27025_38700# 0.06318f
C176 VDD a_46774_43120# 0.58394f
C177 a_5614_38640# a_3667_43909# 0.01988f
C178 VDD a_28854_34502# 0.21515f
C179 a_28444_34502# VDD 0.22431f
C180 a_43147_43909# a_49024_43120# 0.02214f
C181 a_48184_25060# a_48594_25060# 0.0129f
C182 a_46504_25060# a_46914_25060# 0.0129f
C183 a_43004_25060# a_43414_25060# 0.0129f
C184 a_11634_43120# a_3785_43522# 0.01288f
C185 a_26045_43180# a_24247_43909# 0.20754f
C186 a_5347_30329# a_8274_29680# 0.01993f
C187 a_4660_1644# a_1720_1644# 0.04778f
C188 a_3785_43522# a_3667_43909# 0.19076f
C189 a_4240_1644# a_1720_1644# 0.01858f
C190 a_5347_30329# a_7980_29740# 0.20813f
C191 a_5347_30329# a_7864_29680# 0.0137f
C192 a_46914_25060# a_41440_25120# 0.01037f
C193 a_48184_25060# a_41440_25120# 0.04917f
C194 a_45256_25060# a_41440_25120# 0.01072f
C195 a_46504_25060# a_41440_25120# 0.05544f
C196 a_44684_25060# a_41440_25120# 0.0178f
C197 a_43414_25060# a_41440_25120# 0.01384f
C198 a_43004_25060# a_41440_25120# 0.04956f
C199 a_26045_43180# VDD 0.88551f
C200 a_3667_39429# a_8847_25989# 0.53016f
C201 a_41734_25060# a_41440_25120# 0.01483f
C202 a_41734_25060# a_41324_25060# 0.0129f
C203 a_51114_43120# VDD 0.60275f
C204 a_5347_30329# a_3785_25120# 0.02337f
C205 a_24247_43909# a_27874_43120# 0.01283f
C206 a_41467_43909# a_43414_38640# 0.01988f
C207 a_2980_1644# a_1720_1644# 0.04778f
C208 a_2560_1644# a_1720_1644# 0.03212f
C209 a_41440_25120# a_41324_25060# 0.04076f
C210 a_31804_43120# VDD 0.63223f
C211 a_3667_39429# a_1720_1644# 0.41482f
C212 a_43147_43909# MAG 0.06541f
C213 a_3667_39429# a_3667_43909# 0.11878f
C214 a_11740_1644# a_41440_25120# 0.06129f
C215 a_30534_43120# a_30240_43180# 0.01648f
C216 a_29694_25060# a_29284_25060# 0.0129f
C217 VDD a_27874_43120# 0.58394f
C218 a_43147_43909# VDD 2.38686f
C219 a_41467_43909# a_41734_38982# 0.01732f
C220 a_24247_43909# a_30124_43120# 0.02214f
C221 a_27464_43120# a_22685_43522# 0.01772f
C222 a_28014_25060# a_27604_25060# 0.0129f
C223 a_1320_1644# a_1720_1644# 0.0202f
C224 a_41467_43909# a_41467_39429# 0.11878f
C225 a_12904_43120# a_11340_43180# 0.01509f
C226 a_9954_34502# VDD 0.21693f
C227 a_30124_43120# VDD 0.58317f
C228 a_11224_43120# a_11340_43180# 0.04076f
C229 a_41585_43522# a_49140_43180# 0.16289f
C230 a_11740_1644# a_22540_25120# 0.12996f
C231 a_29284_25060# a_22540_25120# 0.04917f
C232 a_28014_25060# a_22540_25120# 0.01037f
C233 a_22540_25120# a_27604_25060# 0.05544f
C234 a_22567_25989# a_41440_25120# 0.14329f
C235 a_49024_43120# VDD 0.58317f
C236 a_24514_25060# a_24104_25060# 0.0129f
C237 a_26356_25060# a_22540_25120# 0.01072f
C238 a_11740_1644# a_22567_25989# 1.8037f
C239 a_22834_43462# a_22685_43522# 0.01511f
C240 a_25784_25060# a_22540_25120# 0.0178f
C241 a_24104_25060# a_22540_25120# 0.04956f
C242 a_48594_25060# a_45780_29740# 0.04066f
C243 a_24514_25060# a_22540_25120# 0.01384f
C244 a_8847_25989# a_41440_25120# 0.05829f
C245 a_45780_29740# a_46914_25060# 0.05266f
C246 SIGN a_11340_43180# 0.38275f
C247 a_48184_25060# a_45780_29740# 0.01552f
C248 VDD a_11340_43180# 0.94704f
C249 a_3667_39429# a_7980_29740# 0.02617f
C250 a_11740_1644# a_8847_25989# 0.23697f
C251 a_22540_25120# a_22834_25060# 0.01483f
C252 a_24247_43909# a_35574_43462# 0.01296f
C253 a_43147_43909# a_54474_43462# 0.01296f
C254 a_45925_38700# a_43147_30329# 0.14279f
C255 VDD a_12904_43120# 0.63223f
C256 a_3667_39429# a_5614_29680# 0.02871f
C257 a_22424_25060# a_22834_25060# 0.0129f
C258 a_30240_43180# a_22685_43522# 0.16289f
C259 a_45925_38700# a_41585_43522# 0.38327f
C260 a_43414_25060# a_41585_25120# 0.04066f
C261 a_22424_25060# a_22540_25120# 0.04076f
C262 a_43004_25060# a_41585_25120# 0.01552f
C263 a_41440_25120# a_5347_25989# 0.06179f
C264 a_22567_25989# a_22540_25120# 0.06129f
C265 a_11740_1644# a_5347_25989# 0.23138f
C266 a_41734_25060# a_41585_25120# 0.05124f
C267 a_3667_39429# a_3785_25120# 0.10361f
C268 SIGN a_11224_43120# 0.02214f
C269 a_11224_43120# VDD 0.58317f
C270 a_27464_43120# a_26045_43180# 0.04961f
C271 CLK a_24247_30329# 0.11777f
C272 a_45780_29740# a_41440_25120# 0.58568f
C273 CLK a_24247_43909# 0.04359f
C274 a_45925_38700# a_46074_38640# 0.02481f
C275 a_11740_1644# a_1720_1644# 1.26744f
C276 a_41467_43909# a_44945_43180# 0.05138f
C277 a_24247_30329# VDD 3.26065f
C278 a_26764_38640# VDD 0.36665f
C279 a_24247_43909# VDD 1.58447f
C280 VDD a_22834_34502# 0.21462f
C281 a_41734_43462# a_41585_43522# 0.01511f
C282 INN INP 3.78345f
C283 a_45094_43120# VDD 0.60019f
C284 a_22424_34502# VDD 0.22567f
C285 a_8847_25989# a_22540_25120# 0.05829f
C286 a_51114_43120# a_49140_43180# 0.04066f
C287 a_41585_25120# a_41440_25120# 0.66682f
C288 a_9954_34502# a_5347_30329# 0.01149f
C289 CLK SIGN 0.04359f
C290 MAG VDD 1.18186f
C291 CLK VDD 15.4685f
C292 a_11740_1644# a_41585_25120# 0.06928f
C293 a_22567_39429# a_24514_34160# 0.02659f
C294 a_41467_39429# a_43414_38640# 0.01094f
C295 a_10384_25060# a_10794_25060# 0.0129f
C296 SIGN a_7145_43180# 0.20754f
C297 VDD a_7145_43180# 0.88551f
C298 VDD a_3934_34502# 0.21462f
C299 SIGN VDD 4.45945f
C300 a_8847_25989# a_22567_25989# 0.24856f
C301 a_31804_43120# a_32214_43120# 0.0129f
C302 a_27464_43120# a_27874_43120# 0.0129f
C303 a_29694_25060# a_26880_29740# 0.04066f
C304 a_9114_25060# a_8704_25060# 0.0129f
C305 a_41467_39429# a_22567_25989# 0.41482f
C306 a_26880_29740# a_29284_25060# 0.01552f
C307 a_26880_29740# a_11740_1644# 0.59303f
C308 a_22540_25120# a_5347_25989# 0.06179f
C309 a_26880_29740# a_28014_25060# 0.05266f
C310 a_22685_43522# a_58100_22740# 0.03463f
C311 a_43147_43909# a_49140_43180# 0.38275f
C312 a_41467_43909# a_41585_43522# 0.19076f
C313 VDD a_45664_38640# 0.36665f
C314 a_44945_43180# a_46364_43120# 0.04961f
C315 a_22567_43909# a_22834_38982# 0.01732f
C316 a_22567_25989# a_5347_25989# 0.23005f
C317 a_41467_39429# a_8847_25989# 0.10995f
C318 a_22567_25989# a_1720_1644# 0.41078f
C319 a_3640_25120# a_10384_25060# 0.04917f
C320 a_3640_25120# a_9114_25060# 0.01037f
C321 a_22567_25989# a_45780_29740# 0.5961f
C322 a_11740_1644# a_22685_25120# 0.12245f
C323 a_8847_25989# a_5347_25989# 0.22321f
C324 a_3640_25120# a_8847_25989# 0.05829f
C325 a_3640_25120# a_8704_25060# 0.05544f
C326 a_3640_25120# a_7456_25060# 0.01072f
C327 a_8847_25989# a_1720_1644# 0.36367f
C328 a_5614_25060# a_5204_25060# 0.0129f
C329 a_26880_29740# a_22540_25120# 0.58568f
C330 a_22567_25989# a_41585_25120# 0.04359f
C331 a_8847_25989# a_45780_29740# 0.11209f
C332 a_3640_25120# a_6884_25060# 0.0178f
C333 a_3640_25120# a_5614_25060# 0.01384f
C334 a_6884_43120# a_7294_43120# 0.0129f
C335 a_41467_39429# a_45780_29740# 0.02886f
C336 a_24104_25060# a_22685_25120# 0.01552f
C337 a_22567_43909# a_24514_38640# 0.01988f
C338 a_24514_25060# a_22685_25120# 0.04066f
C339 a_3640_25120# a_5204_25060# 0.04956f
C340 a_27174_38640# VDD 0.3476f
C341 a_22567_39429# a_24514_38640# 0.01094f
C342 a_41585_43522# a_46364_43120# 0.01772f
C343 a_43004_38640# VDD 0.36377f
C344 a_5614_34160# VDD 0.3476f
C345 a_41467_39429# a_43414_29680# 0.02871f
C346 VDD a_7864_34160# 0.36279f
C347 a_3640_25120# a_5347_25989# 0.06179f
C348 a_43147_43909# a_45925_38700# 0.10869f
C349 a_3524_25060# a_3934_25060# 0.0129f
C350 a_8847_25989# a_41585_25120# 0.01807f
C351 a_3640_25120# a_3934_25060# 0.01483f
C352 a_16220_3370# VDD 0.01044f
C353 a_24247_43909# a_33894_43462# 0.01296f
C354 a_3640_25120# a_3524_25060# 0.04076f
C355 a_22685_25120# a_22834_25060# 0.05124f
C356 a_30240_43180# a_31804_43120# 0.01509f
C357 a_49140_43180# a_49024_43120# 0.04076f
C358 a_11740_1644# a_22685_43522# 0.86773f
C359 a_5347_25989# a_1720_1644# 0.77572f
C360 a_3640_25120# a_1720_1644# 0.12103f
C361 a_41467_39429# a_41585_25120# 0.10361f
C362 a_22685_25120# a_22540_25120# 0.66594f
C363 a_49434_43120# a_41585_43522# 0.01288f
C364 a_26045_43180# a_26194_43120# 0.04654f
C365 a_47754_30022# a_45780_29740# 0.01149f
C366 a_46364_43120# a_46774_43120# 0.0129f
C367 a_26880_29740# a_8847_25989# 0.28139f
C368 a_46074_29680# a_45780_29740# 0.01311f
C369 CLK a_5347_30329# 0.12136f
C370 a_45664_29680# a_45780_29740# 0.01998f
C371 VDD a_9544_34502# 0.22431f
C372 a_22567_25989# a_22685_25120# 0.06928f
C373 a_22567_39429# a_11740_1644# 0.87502f
C374 a_5347_30329# VDD 3.2999f
C375 a_27025_38700# a_22685_43522# 0.38327f
C376 a_41585_25120# a_5347_25989# 0.27323f
C377 a_11340_43180# a_13314_43120# 0.04066f
C378 a_24104_38640# VDD 0.36377f
C379 a_14994_43462# SIGN 0.01296f
C380 a_11340_43180# a_3785_43522# 0.16289f
C381 a_26880_29740# a_5347_25989# 0.0412f
C382 a_8847_25989# a_22685_25120# 0.17958f
C383 a_12904_43120# a_13314_43120# 0.0129f
C384 a_43004_29680# a_41585_25120# 0.02887f
C385 a_30240_43180# a_30124_43120# 0.04076f
C386 a_10384_25060# a_7980_29740# 0.01552f
C387 a_9114_25060# a_7980_29740# 0.05266f
C388 a_27464_43120# a_24247_43909# 0.01306f
C389 a_7980_29740# a_10794_25060# 0.04066f
C390 a_41734_30022# a_41585_25120# 0.01511f
C391 a_43414_43462# a_41585_43522# 0.01595f
C392 a_8847_25989# a_7980_29740# 0.28139f
C393 a_22567_25989# a_22685_43522# 0.63154f
C394 a_41467_43909# a_43147_43909# 0.11516f
C395 a_22685_25120# a_5347_25989# 0.3073f
C396 a_22567_25989# a_43147_30329# 0.75417f
C397 a_11224_43120# a_3785_43522# 0.01581f
C398 VDD a_5614_38640# 0.34967f
C399 a_28854_30022# a_26880_29740# 0.01149f
C400 a_27464_43120# VDD 0.58253f
C401 a_27174_29680# a_26880_29740# 0.01311f
C402 a_8847_25989# a_22685_43522# 0.11334f
C403 VDD a_32214_43120# 0.60275f
C404 a_43147_43909# a_58100_22740# 0.05288f
C405 a_22567_39429# a_22567_25989# 0.04373f
C406 a_49140_43180# VDD 0.94704f
C407 a_7980_29740# a_5347_25989# 0.0412f
C408 a_3640_25120# a_7980_29740# 0.58568f
C409 a_8847_25989# a_43147_30329# 0.19161f
C410 a_8847_25989# a_3785_25120# 0.17994f
C411 SIGN a_8974_43120# 0.01283f
C412 a_8974_43120# VDD 0.58394f
C413 a_51114_43120# a_50704_43120# 0.0129f
C414 a_7980_29740# a_1720_1644# 0.59303f
C415 a_5347_30329# a_7864_34160# 0.0136f
C416 VDD a_13314_43120# 0.60275f
C417 a_41467_39429# a_43147_30329# 0.76576f
C418 CLK a_3785_43522# 0.03851f
C419 a_26764_29680# a_26880_29740# 0.01998f
C420 a_5204_38640# VDD 0.36377f
C421 a_5614_25060# a_3785_25120# 0.04066f
C422 a_3785_43522# a_7145_43180# 0.37231f
C423 a_22567_39429# a_8847_25989# 0.53016f
C424 SIGN a_3785_43522# 0.69483f
C425 VDD a_3785_43522# 1.74814f
C426 a_22685_43522# a_5347_25989# 0.059f
C427 a_5204_25060# a_3785_25120# 0.01552f
C428 a_41467_39429# a_43414_34160# 0.02853f
C429 a_43147_43909# a_46364_43120# 0.01306f
C430 a_3785_25120# a_5347_25989# 0.3073f
C431 a_41467_39429# a_41734_34502# 0.01511f
C432 a_3785_25120# a_3934_25060# 0.05124f
C433 a_3640_25120# a_3785_25120# 0.66682f
C434 a_3785_25120# a_1720_1644# 0.06928f
C435 a_30534_43120# a_22685_43522# 0.01288f
C436 a_46074_29680# a_43147_30329# 0.01993f
C437 a_45780_29740# a_43147_30329# 0.20813f
C438 a_45664_29680# a_43147_30329# 0.01371f
C439 a_43147_43909# a_52794_43462# 0.01296f
C440 a_43147_43909# a_49434_43120# 0.04353f
C441 a_24247_43909# a_30240_43180# 0.38275f
C442 a_22685_25120# a_24104_29680# 0.02887f
C443 a_22834_30022# a_22685_25120# 0.01386f
C444 a_45925_38700# VDD 1.39801f
C445 VDD a_24104_34160# 0.36505f
C446 a_8274_38640# VDD 0.3476f
C447 a_41585_25120# a_43147_30329# 0.02512f
C448 CLK a_3667_39429# 0.16378f
C449 a_30240_43180# VDD 0.94704f
C450 a_24247_30329# a_27174_34160# 0.02223f
C451 a_3667_39429# a_3934_34502# 0.01511f
C452 a_8440_3766# a_8860_3766# 0.1684f
C453 a_3667_39429# VDD 3.16979f
C454 a_9954_30022# a_7980_29740# 0.01149f
C455 a_26880_29740# a_22567_39429# 0.02617f
C456 VDD a_24514_34160# 0.34727f
C457 a_8274_29680# a_7980_29740# 0.01311f
C458 a_7600_1644# a_8020_1644# 0.1684f
C459 a_7180_3766# a_8440_3766# 0.01209f
C460 MAG a_63434_22680# 0.0228f
C461 VDD a_27174_34160# 0.34888f
C462 a_7864_29680# a_7980_29740# 0.01998f
C463 a_49434_43120# a_49024_43120# 0.0129f
C464 a_6340_1644# a_7600_1644# 0.01209f
C465 VDD a_63434_22680# 0.35048f
C466 a_22567_39429# a_24514_29680# 0.02871f
C467 MAG a_63024_22680# 0.01113f
C468 a_7180_3766# a_6760_3766# 0.1684f
C469 a_61344_22680# MAG 0.01113f
C470 a_61754_22680# MAG 0.0228f
C471 VDD a_26194_43120# 0.60019f
C472 a_41467_43909# CLK 0.03709f
C473 a_22567_39429# a_22685_25120# 0.10361f
C474 a_5204_34160# VDD 0.36665f
C475 a_6340_1644# a_5920_1644# 0.1684f
C476 VDD a_63024_22680# 0.36293f
C477 a_61344_22680# VDD 0.36279f
C478 a_61754_22680# VDD 0.35048f
C479 a_58394_22680# MAG 0.02496f
C480 a_41585_43522# a_44945_43180# 0.37231f
C481 a_41467_43909# VDD 1.29151f
C482 a_5500_3766# a_6760_3766# 0.01209f
C483 MAG a_58100_22740# 0.39581f
C484 a_3667_39429# a_5614_34160# 0.02853f
C485 a_3785_25120# a_5204_29680# 0.02887f
C486 a_8125_38700# a_11340_43180# 0.06318f
C487 a_24514_43462# a_22685_43522# 0.01595f
C488 a_3785_25120# a_3934_30022# 0.01386f
C489 a_43147_30329# a_47754_34502# 0.01149f
C490 a_22567_43909# a_22685_43522# 0.19076f
C491 a_43147_30329# a_46074_34160# 0.02223f
C492 VDD a_25784_43120# 0.63479f
C493 a_4660_1644# a_5920_1644# 0.01209f
C494 a_5080_3766# a_5500_3766# 0.1684f
C495 a_45664_34160# a_43147_30329# 0.0136f
C496 a_28854_38982# a_27025_38700# 0.0139f
C497 VDD a_24514_38640# 0.34967f
C498 a_8274_34160# VDD 0.35048f
R0 CLK.n1 CLK.t0 66.9351
R1 CLK.n1 CLK.t1 66.9351
R2 CLK.n6 CLK.t2 66.9351
R3 CLK.n6 CLK.t3 66.9351
R4 CLK.n10 CLK.n4 66.6905
R5 CLK.n0 CLK.t9 64.4465
R6 CLK.n5 CLK.t11 64.4465
R7 CLK.n3 CLK.t6 57.3995
R8 CLK.n8 CLK.t8 57.3995
R9 CLK.n4 CLK.t10 52.5086
R10 CLK.n9 CLK.t12 52.5086
R11 CLK.n0 CLK.t5 48.7505
R12 CLK.n5 CLK.t7 48.7505
R13 CLK.n10 CLK.n9 38.3645
R14 CLK.t4 CLK.n10 37.5125
R15 CLK CLK.t4 21.2705
R16 CLK.n2 CLK.n1 19.6209
R17 CLK.n7 CLK.n6 19.6209
R18 CLK.n4 CLK.n3 11.5925
R19 CLK.n9 CLK.n8 11.5925
R20 CLK.n3 CLK.n2 11.4065
R21 CLK.n8 CLK.n7 11.4065
R22 CLK.n2 CLK.n0 5.3165
R23 CLK.n7 CLK.n5 5.3165
C499 INP VSS 10.9702f
C500 INN VSS 18.9667f
C501 MAG VSS 5.09102f
C502 CLK VSS 51.22068f
C503 SIGN VSS 31.3542f
C504 VDD VSS 0.48002p
C505 a_29660_1644# VSS 4.72673f ; **FLOATING
C506 a_27420_3253# VSS 4.76546f ; **FLOATING
C507 a_18460_1644# VSS 4.39198f ; **FLOATING
C508 a_16220_3370# VSS 4.38724f ; **FLOATING
C509 a_13980_1644# VSS 4.3966f ; **FLOATING
C510 a_11740_3370# VSS 4.40625f ; **FLOATING
C511 a_10100_1644# VSS 2.63556f
C512 a_8860_3766# VSS 0.86356f ; **FLOATING
C513 a_8440_3766# VSS 0.85051f ; **FLOATING
C514 a_8020_1644# VSS 0.8497f ; **FLOATING
C515 a_7600_1644# VSS 0.85205f ; **FLOATING
C516 a_7180_3766# VSS 0.85871f ; **FLOATING
C517 a_6760_3766# VSS 0.85051f ; **FLOATING
C518 a_6340_1644# VSS 0.85871f ; **FLOATING
C519 a_5920_1644# VSS 0.85457f ; **FLOATING
C520 a_5500_3766# VSS 0.85871f ; **FLOATING
C521 a_5080_3766# VSS 0.85051f ; **FLOATING
C522 a_4660_1644# VSS 0.85871f ; **FLOATING
C523 a_4240_1644# VSS 0.85533f ; **FLOATING
C524 a_3820_3766# VSS 0.85871f ; **FLOATING
C525 a_3400_3766# VSS 0.85051f ; **FLOATING
C526 a_2980_1644# VSS 0.85871f ; **FLOATING
C527 a_2560_1644# VSS 0.85373f ; **FLOATING
C528 a_2140_3766# VSS 0.85871f ; **FLOATING
C529 a_1720_3766# VSS 0.85495f ; **FLOATING
C530 a_1320_1644# VSS 2.63799f
C531 a_63434_22680# VSS 0.04368f
C532 a_63024_22680# VSS 0.04368f
C533 a_61754_22680# VSS 0.04368f
C534 a_61344_22680# VSS 0.04368f
C535 a_60074_22680# VSS 0.39521f
C536 a_59664_22680# VSS 0.40738f ; **FLOATING
C537 a_58394_22680# VSS 0.38453f
C538 a_58100_22740# VSS 0.97755f ; **FLOATING
C539 a_57984_22680# VSS 0.38639f
C540 a_48594_25060# VSS 0.65977f
C541 a_48184_25060# VSS 0.65679f
C542 a_46914_25060# VSS 0.65977f
C543 a_46504_25060# VSS 0.65832f
C544 a_45256_25060# VSS 0.74138f
C545 a_44684_25060# VSS 0.74083f
C546 a_43414_25060# VSS 0.65977f
C547 a_43004_25060# VSS 0.65679f
C548 a_41734_25060# VSS 0.65883f
C549 a_41440_25120# VSS 3.96893f ; **FLOATING
C550 a_41324_25060# VSS 0.65774f
C551 a_29694_25060# VSS 0.65977f
C552 a_29284_25060# VSS 0.65679f
C553 a_11740_1644# VSS 89.5272f ; **FLOATING
C554 a_28014_25060# VSS 0.65977f
C555 a_27604_25060# VSS 0.65832f
C556 a_26356_25060# VSS 0.74138f
C557 a_25784_25060# VSS 0.74083f
C558 a_24514_25060# VSS 0.65977f
C559 a_24104_25060# VSS 0.65679f
C560 a_22834_25060# VSS 0.65883f
C561 a_22540_25120# VSS 3.97768f ; **FLOATING
C562 a_22424_25060# VSS 0.65774f
C563 a_22567_25989# VSS 97.8111f ; **FLOATING
C564 a_10794_25060# VSS 0.65977f
C565 a_10384_25060# VSS 0.65679f
C566 a_9114_25060# VSS 0.65977f
C567 a_8704_25060# VSS 0.65832f
C568 a_8847_25989# VSS 65.8339f ; **FLOATING
C569 a_7456_25060# VSS 0.74138f
C570 a_6884_25060# VSS 0.74083f
C571 a_5614_25060# VSS 0.65977f
C572 a_5204_25060# VSS 0.65679f
C573 a_5347_25989# VSS 59.3193f ; **FLOATING
C574 a_3934_25060# VSS 0.65883f
C575 a_3640_25120# VSS 4.01893f ; **FLOATING
C576 a_3524_25060# VSS 0.65774f
C577 a_1720_1644# VSS 0.1003p ; **FLOATING
C578 a_47754_30022# VSS 0.02717f
C579 a_47344_30022# VSS 0.02717f
C580 a_46074_29680# VSS 0.38483f
C581 a_45780_29740# VSS 2.83031f ; **FLOATING
C582 a_45664_29680# VSS 0.38539f
C583 a_43414_29680# VSS 0.38545f
C584 a_43004_29680# VSS 0.38483f
C585 a_41734_30022# VSS 0.02717f
C586 a_41585_25120# VSS 3.10037f ; **FLOATING
C587 a_41324_30022# VSS 0.02717f
C588 a_28854_30022# VSS 0.02717f
C589 a_28444_30022# VSS 0.02717f
C590 a_27174_29680# VSS 0.38401f
C591 a_26880_29740# VSS 2.61695f ; **FLOATING
C592 a_26764_29680# VSS 0.38539f
C593 a_24514_29680# VSS 0.38545f
C594 a_24104_29680# VSS 0.38401f
C595 a_22834_30022# VSS 0.02717f
C596 a_22685_25120# VSS 2.86723f ; **FLOATING
C597 a_22424_30022# VSS 0.02717f
C598 a_9954_30022# VSS 0.02717f
C599 a_9544_30022# VSS 0.02717f
C600 a_8274_29680# VSS 0.38401f
C601 a_7980_29740# VSS 2.61695f ; **FLOATING
C602 a_7864_29680# VSS 0.38539f
C603 a_5614_29680# VSS 0.38545f
C604 a_5204_29680# VSS 0.38401f
C605 a_3934_30022# VSS 0.02717f
C606 a_3785_25120# VSS 2.89632f ; **FLOATING
C607 a_3524_30022# VSS 0.02717f
C608 a_47754_34502# VSS 0.02717f
C609 a_47344_34502# VSS 0.02717f
C610 a_46074_34160# VSS 0.04368f
C611 a_45664_34160# VSS 0.04368f
C612 a_43414_34160# VSS 0.04368f
C613 a_43004_34160# VSS 0.04368f
C614 a_41734_34502# VSS 0.02717f
C615 a_41324_34502# VSS 0.02717f
C616 a_28854_34502# VSS 0.02717f
C617 a_28444_34502# VSS 0.02717f
C618 a_27174_34160# VSS 0.04368f
C619 a_26764_34160# VSS 0.04368f
C620 a_24514_34160# VSS 0.04368f
C621 a_24104_34160# VSS 0.04368f
C622 a_22834_34502# VSS 0.02717f
C623 a_22424_34502# VSS 0.02717f
C624 a_9954_34502# VSS 0.02717f
C625 a_9544_34502# VSS 0.02717f
C626 a_8274_34160# VSS 0.04368f
C627 a_7864_34160# VSS 0.04368f
C628 a_5614_34160# VSS 0.04368f
C629 a_5204_34160# VSS 0.04368f
C630 a_3934_34502# VSS 0.02717f
C631 a_3524_34502# VSS 0.02717f
C632 a_47754_38982# VSS 0.24358f
C633 a_47344_38982# VSS 0.25096f ; **FLOATING
C634 a_46074_38640# VSS 0.04368f
C635 a_45664_38640# VSS 0.04368f
C636 a_43147_30329# VSS 6.62039f ; **FLOATING
C637 a_43414_38640# VSS 0.04368f
C638 a_43004_38640# VSS 0.04368f
C639 a_41734_38982# VSS 0.24044f
C640 a_41324_38982# VSS 0.2541f ; **FLOATING
C641 a_41467_39429# VSS 7.51023f ; **FLOATING
C642 a_28854_38982# VSS 0.24358f
C643 a_28444_38982# VSS 0.25096f ; **FLOATING
C644 a_27174_38640# VSS 0.04368f
C645 a_26764_38640# VSS 0.04368f
C646 a_24247_30329# VSS 6.45475f ; **FLOATING
C647 a_24514_38640# VSS 0.04368f
C648 a_24104_38640# VSS 0.04368f
C649 a_22834_38982# VSS 0.24044f
C650 a_22424_38982# VSS 0.2541f ; **FLOATING
C651 a_22567_39429# VSS 7.03562f ; **FLOATING
C652 a_9954_38982# VSS 0.24358f
C653 a_9544_38982# VSS 0.25096f ; **FLOATING
C654 a_8274_38640# VSS 0.04368f
C655 a_7864_38640# VSS 0.04368f
C656 a_5347_30329# VSS 6.51796f ; **FLOATING
C657 a_5614_38640# VSS 0.04368f
C658 a_5204_38640# VSS 0.04368f
C659 a_3934_38982# VSS 0.24044f
C660 a_3524_38982# VSS 0.2541f ; **FLOATING
C661 a_3667_39429# VSS 7.3666f ; **FLOATING
C662 a_54474_43462# VSS 0.24358f
C663 a_54064_43462# VSS 0.25096f ; **FLOATING
C664 a_52794_43462# VSS 0.24358f
C665 a_52384_43462# VSS 0.25096f ; **FLOATING
C666 a_51114_43120# VSS 0.07326f
C667 a_50704_43120# VSS 0.07326f
C668 a_45925_38700# VSS 5.35825f ; **FLOATING
C669 a_49434_43120# VSS 0.07326f
C670 a_49140_43180# VSS 0.55804f ; **FLOATING
C671 a_49024_43120# VSS 0.07326f
C672 a_46774_43120# VSS 0.07326f
C673 a_46364_43120# VSS 0.07326f
C674 a_45094_43120# VSS 0.07326f
C675 a_44945_43180# VSS 0.40798f ; **FLOATING
C676 a_44684_43120# VSS 0.07326f
C677 a_43414_43462# VSS 0.24275f
C678 a_43004_43462# VSS 0.2518f ; **FLOATING
C679 a_43147_43909# VSS 14.2692f ; **FLOATING
C680 a_41734_43462# VSS 0.24044f
C681 a_41585_43522# VSS 7.49772f ; **FLOATING
C682 a_41324_43462# VSS 0.2541f ; **FLOATING
C683 a_41467_43909# VSS 4.20902f ; **FLOATING
C684 a_35574_43462# VSS 0.24358f
C685 a_35164_43462# VSS 0.25096f ; **FLOATING
C686 a_33894_43462# VSS 0.24358f
C687 a_33484_43462# VSS 0.25096f ; **FLOATING
C688 a_32214_43120# VSS 0.07326f
C689 a_31804_43120# VSS 0.07326f
C690 a_27025_38700# VSS 5.35294f ; **FLOATING
C691 a_30534_43120# VSS 0.07326f
C692 a_30240_43180# VSS 0.55804f ; **FLOATING
C693 a_30124_43120# VSS 0.07326f
C694 a_27874_43120# VSS 0.07326f
C695 a_27464_43120# VSS 0.07326f
C696 a_26194_43120# VSS 0.07326f
C697 a_26045_43180# VSS 0.40798f ; **FLOATING
C698 a_25784_43120# VSS 0.07326f
C699 a_24514_43462# VSS 0.24275f
C700 a_24104_43462# VSS 0.2518f ; **FLOATING
C701 a_24247_43909# VSS 9.54553f ; **FLOATING
C702 a_22834_43462# VSS 0.24044f
C703 a_22685_43522# VSS 20.0433f ; **FLOATING
C704 a_22424_43462# VSS 0.2541f ; **FLOATING
C705 a_22567_43909# VSS 4.20494f ; **FLOATING
C706 a_16674_43462# VSS 0.24358f
C707 a_16264_43462# VSS 0.25096f ; **FLOATING
C708 a_14994_43462# VSS 0.24358f
C709 a_14584_43462# VSS 0.25096f ; **FLOATING
C710 a_13314_43120# VSS 0.07326f
C711 a_12904_43120# VSS 0.07326f
C712 a_8125_38700# VSS 5.35294f ; **FLOATING
C713 a_11634_43120# VSS 0.07326f
C714 a_11340_43180# VSS 0.55804f ; **FLOATING
C715 a_11224_43120# VSS 0.07326f
C716 a_8974_43120# VSS 0.07326f
C717 a_8564_43120# VSS 0.07326f
C718 a_7294_43120# VSS 0.07326f
C719 a_7145_43180# VSS 0.40798f ; **FLOATING
C720 a_6884_43120# VSS 0.07326f
C721 a_5614_43462# VSS 0.24275f
C722 a_5204_43462# VSS 0.2518f ; **FLOATING
C723 a_3934_43462# VSS 0.24044f
C724 a_3785_43522# VSS 7.4939f ; **FLOATING
C725 a_3524_43462# VSS 0.2541f ; **FLOATING
C726 a_3667_43909# VSS 4.20494f ; **FLOATING
C727 CLK.t5 VSS 0.0564f ; **FLOATING
C728 CLK.t9 VSS 0.17653f ; **FLOATING
C729 CLK.n0 VSS 0.93974f ; **FLOATING
C730 CLK.t0 VSS 0.09446f ; **FLOATING
C731 CLK.t1 VSS 0.09446f ; **FLOATING
C732 CLK.n1 VSS 0.40773f ; **FLOATING
C733 CLK.n2 VSS 0.8331f ; **FLOATING
C734 CLK.t6 VSS 0.07873f ; **FLOATING
C735 CLK.n3 VSS 0.8164f ; **FLOATING
C736 CLK.t10 VSS 0.0633f ; **FLOATING
C737 CLK.n4 VSS 2.4597f ; **FLOATING
C738 CLK.t7 VSS 0.0564f ; **FLOATING
C739 CLK.t11 VSS 0.17653f ; **FLOATING
C740 CLK.n5 VSS 0.93974f ; **FLOATING
C741 CLK.t2 VSS 0.09446f ; **FLOATING
C742 CLK.t3 VSS 0.09446f ; **FLOATING
C743 CLK.n6 VSS 0.40773f ; **FLOATING
C744 CLK.n7 VSS 0.8331f ; **FLOATING
C745 CLK.t8 VSS 0.07873f ; **FLOATING
C746 CLK.n8 VSS 0.8164f ; **FLOATING
C747 CLK.t12 VSS 0.0633f ; **FLOATING
C748 CLK.n9 VSS 1.6936f ; **FLOATING
C749 CLK.n10 VSS 4.47611f ; **FLOATING
C750 CLK.t4 VSS 7.35305f ; **FLOATING
.ends
