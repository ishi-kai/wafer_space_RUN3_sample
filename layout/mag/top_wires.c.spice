* NGSPICE file created from top_wires_flat.ext - technology: gf180mcuD

.subckt top_wires_flat
C0 mqn ckr 0.03901f
C1 mqp ICP2 0.03761f
C2 AFCOUT aqp 0.04359f
C3 ICP2 fs 0.03596f
C4 B0 IG1B 0.04427f
C5 IG3B IG2A 0.04359f
C6 aqn IG2B 0.04359f
C7 IG3A BWN 0.04359f
C8 nb IG1B 0.04348f
C9 refck ckr 0.04457f
C10 min ain 1.06619f
C11 mip IG2A 0.07316f
C12 pb aqp 0.03676f
C13 AFC7 BWN 0.03901f
C14 fs BWK 0.03791f
C15 min refck 0.03676f
C16 l2p l2n 0.27954f
C17 mqp refck_a 0.04359f
C18 pb B1 0.03676f
C19 nb AFC6 0.04457f
C20 min l3p 0.03901f
C21 refck_a fs 6.28322f
C22 AFC7 I_MAG 0.04457f
C23 AFC3 I_SIGN 5.71864f
C24 AFC1 fs 0.03234f
C25 vctrl_i refck_a 0.04359f
C26 pb ckr 0.04457f
C27 ICP2 BWK 0.04457f
C28 B0 ain 0.04457f
C29 IG3B IG1A 0.03849f
C30 aqn IG1B 0.05041f
C31 IG3A IG2A 0.04359f
C32 pb min 0.0412f
C33 mqn nb 0.07249f
C34 B1 ckr 0.03901f
C35 refck_a ICP2 0.2306f
C36 mip IG1A 0.0306f
C37 AFC1 ICP2 0.05291f
C38 I_SIGN BWN 0.06485f
C39 fs AFC5 0.03791f
C40 min B1 0.03849f
C41 nb refck 0.1238f
C42 mip l3n 0.03676f
C43 pb Q_SIGN 0.10468f
C44 refck_a BWK 0.00298f
C45 AFC3 AFC6 0.04762f
C46 I_MAG I_SIGN 3.45835f
C47 AFC1 BWK 0.06986f
C48 AFC0 AFC2 0.04457f
C49 nb AFCOUT 0.03849f
C50 min ckr 1.33131f
C51 mqn aqn 0.03676f
C52 pb B0 0.03676f
C53 AFCOUT Q_MAG 0.04457f
C54 ICP2 AFC5 0.0412f
C55 IG3B fs 0.04359f
C56 IG3A IG1A 0.03849f
C57 IG2B IG2A 0.82903f
C58 AFC0 Q_SIGN 0.04348f
C59 mqp mip 0.07489f
C60 pb nb 0.16139f
C61 nb aqp 0.04359f
C62 B1 B0 17.0673f
C63 pb Q_MAG 0.03901f
C64 AFC6 BWN 0.03901f
C65 AFC4 fs 0.03596f
C66 aip IG3B 0.04457f
C67 BWK AFC5 0.04359f
C68 nb B1 0.03676f
C69 mip vctrl_i 0.03167f
C70 AFCOUT aqn 0.04359f
C71 mip aip 0.26784f
C72 l2p l4n 0.14597f
C73 vmon l3p 0.08607f
C74 ckr B0 0.03901f
C75 I_MAG AFC6 1.87912f
C76 Q_SIGN AFC2 0.04348f
C77 AFC1 AFC5 0.04326f
C78 vmon AFCOUT 0.04359f
C79 min B0 0.03849f
C80 mip ICP2 0.03676f
C81 nb ckr 0.73646f
C82 pb aqn 0.04427f
C83 mqn BWN 0.03676f
C84 AFC4 ICP2 1.95441f
C85 aqn aqp 1.38717f
C86 IG3A fs 0.04359f
C87 IG2B IG1A 0.03849f
C88 IG2A IG1B 6.19646f
C89 min nb 0.11884f
C90 nb AFC2 0.04457f
C91 mip BWK 3.29832f
C92 AFC4 BWK 0.03791f
C93 AFC7 fs 0.03791f
C94 aip IG3A 0.04457f
C95 nb Q_SIGN 0.03557f
C96 l2n l3p 0.3875f
C97 vtn IG3B 0.04359f
C98 AFC3 AFC0 0.03791f
C99 AFC4 AFC1 0.50666f
C100 mip vtn 0.04359f
C101 nb B0 0.03676f
C102 pb BWN 9.389f
C103 AFC7 ICP2 0.04457f
C104 BWN aqp 0.03676f
C105 IG2B fs 0.04359f
C106 IG1B IG1A 8.77154f
C107 IG2A ain 0.08786f
C108 nb Q_MAG 0.04457f
C109 AFC0 BWN 0.03234f
C110 AFC7 BWK 0.04457f
C111 I_MAG aqp 0.04262f
C112 aip IG2B 0.04457f
C113 I_SIGN fs 0.08816f
C114 AFC4 AFC5 0.11759f
C115 AFC3 AFC2 0.04359f
C116 vtn IG3A 0.04359f
C117 AFC3 Q_SIGN 0.04348f
C118 I_MAG AFC0 0.03761f
C119 AFC7 AFC1 0.08063f
C120 mip IG3B 0.03849f
C121 nb aqn 0.84188f
C122 pb IG2A 0.04322f
C123 I_SIGN ICP2 0.03917f
C124 BWN AFC2 0.70414f
C125 IG1B fs 0.04359f
C126 IG1A ain 2.67481f
C127 IG2B BWK 0.0412f
C128 mqn l3n 0.03676f
C129 nb AFC3 0.04457f
C130 B1 IG2A 0.04322f
C131 Q_SIGN BWN 0.03557f
C132 AFC6 fs 0.03761f
C133 aip IG1B 0.04427f
C134 I_SIGN BWK 0.03917f
C135 AFC7 AFC5 0.04359f
C136 I_MAG AFC2 0.04322f
C137 pb RFIN 2.69223f
C138 mqp VCTRL 0.03676f
C139 l3n l3p 0.46641f
C140 vtn IG2B 0.04359f
C141 IG3B IG3A 0.04359f
C142 I_SIGN AFC1 1.81531f
C143 I_MAG Q_SIGN 0.52129f
C144 mqn mqp 38.3385f
C145 refck REFIN 0.07634f
C146 mip IG3A 0.0418f
C147 min IG2A 0.07999f
C148 nb BWN 0.52348f
C149 pb IG1A 0.04322f
C150 AFC6 ICP2 0.04457f
C151 BWN Q_MAG 0.03901f
C152 IG1B BWK 0.03871f
C153 ain fs 0.03564f
C154 mqn vctrl_i 0.03167f
C155 mqp refck 0.03676f
C156 REFIN AFCOUT 0.04177f
C157 mqp l3p 0.03901f
C158 B1 IG1A 0.04359f
C159 AFC4 AFC7 0.1329f
C160 I_MAG Q_MAG 0.00528f
C161 I_SIGN AFC5 0.03749f
C162 AFC6 BWK 0.08153f
C163 aip ain 0.08816f
C164 mqn ICP2 1.53184f
C165 B0 IG2A 0.04322f
C166 IG3B IG2B 0.04359f
C167 aqn BWN 0.04359f
C168 AFC6 AFC1 1.71629f
C169 mqp pb 0.04359f
C170 vctrl_i AFCOUT 0.03849f
C171 refck ICP2 0.04457f
C172 mip IG2B 0.04359f
C173 min IG1A 0.05769f
C174 nb IG2A 0.05616f
C175 AFC3 BWN 0.04457f
C176 I_MAG aqn 0.04262f
C177 fs aqp 0.29576f
C178 min l3n 0.03676f
C179 B1 fs 0.04359f
C180 AFC3 I_MAG 0.04427f
C181 AFC4 I_SIGN 0.72878f
C182 AFC0 fs 11.5916f
C183 AFC6 AFC5 0.04322f
C184 vctrl_i B1 0.04023f
C185 mqp ckr 0.03901f
C186 pb ICP2 0.09118f
C187 B1 aip 0.04457f
C188 ICP2 aqp 0.04359f
C189 B0 IG1A 0.04359f
C190 IG3B IG1B 0.92906f
C191 aqn IG2A 0.03849f
C192 IG3A IG2B 0.04359f
C193 refck_a AFCOUT 0.04457f
C194 mip IG1B 0.07666f
C195 nb IG1A 0.09407f
C196 B1 ICP2 0.03676f
C197 vctrl_i ckr 0.27169f
C198 pb BWK 1.85617f
C199 AFC0 ICP2 0.03596f
C200 I_MAG BWN 0.03345f
C201 fs AFC2 0.04359f
C202 aqp BWK 0.04359f
C203 min vctrl_i 0.03167f
C204 pb refck_a 0.04322f
C205 min aip 1.16496f
C206 ICP2 ckr 0.04359f
C207 AFC7 I_SIGN 0.13189f
C208 AFC4 AFC6 0.04388f
C209 AFC0 BWK 0.03791f
C210 Q_SIGN fs 0.05551f
C211 mip VCTRL 0.03676f
C212 min ICP2 0.03676f
C213 pb vtn 0.04359f
C214 IG3B ain 0.04457f
C215 ICP2 AFC2 0.0412f
C216 B0 fs 0.04359f
C217 aqn IG1A 0.03676f
C218 IG3A IG1B 0.03849f
C219 AFC0 AFC1 0.03234f
C220 mqn mip 0.52105f
C221 mqp nb 0.07489f
C222 min BWK 1.51792f
C223 mip ain 1.17165f
C224 B1 vtn 0.03676f
C225 vctrl_i B0 0.04023f
C226 pb AFC5 0.03901f
C227 Q_SIGN ICP2 0.03791f
C228 aip B0 0.04457f
C229 fs Q_MAG 0.04457f
C230 BWK AFC2 0.04359f
C231 nb vctrl_i 12.4863f
C232 mip refck 0.03676f
C233 vmon l3n 0.1347f
C234 mip l3p 0.03901f
C235 ICP2 B0 0.03676f
C236 AFC7 AFC6 0.04019f
C237 Q_SIGN BWK 0.03791f
C238 AFC0 AFC5 0.03791f
C239 AFC1 AFC2 0.04326f
C240 vmon REFIN 0.04359f
C241 min vtn 0.04359f
C242 nb ICP2 0.12837f
C243 mqp aqn 0.03676f
C244 pb IG3B 0.04359f
C245 ICP2 Q_MAG 0.04457f
C246 aqn fs 0.03564f
C247 IG2B IG1B 0.03849f
C248 IG3A ain 0.08816f
C249 AFC1 Q_SIGN 0.04348f
C250 pb mip 0.04322f
C251 rfn nb 0.19799f
C252 nb BWK 0.00268f
C253 B1 IG3B 0.04457f
C254 AFC3 fs 0.03791f
C255 BWK Q_MAG 0.04457f
C256 AFC2 AFC5 0.04359f
C257 nb refck_a 0.04322f
C258 mip B1 0.03849f
C259 l2n l3n 0.89747f
C260 l2p l3p 0.01791f
C261 ICP2 aqn 0.04359f
C262 vtn B0 0.03676f
C263 AFC4 AFC0 0.03596f
C264 I_SIGN AFC6 1.60208f
C265 Q_SIGN AFC5 0.03791f
C266 mip ckr 0.03901f
C267 min IG3B 0.08208f
C268 nb vtn 0.0918f
C269 mqp BWN 0.03676f
C270 pb IG3A 0.04359f
C271 AFC3 ICP2 0.04262f
C272 BWN fs 0.03234f
C273 aqn BWK 0.04427f
C274 IG2A IG1A 0.03849f
C275 IG2B ain 0.08816f
C276 min mip 29.7674f
C277 rfp nb 0.20299f
C278 pb AFC7 0.03901f
C279 nb AFC5 0.04457f
C280 B1 IG3A 0.04359f
C281 AFC3 BWK 0.04457f
C282 I_MAG fs 0.08218f
C283 AFC4 AFC2 0.0412f
C284 B0 IG3B 0.04457f
C285 ICP2 BWN 0.04359f
C286 vtn aqn 0.04359f
C287 AFC4 Q_SIGN 3.57658f
C288 AFC7 AFC0 0.03791f
C289 AFC3 AFC1 0.49949f
C290 mip B0 0.03849f
C291 min IG3A 0.08539f
C292 nb IG3B 0.05616f
C293 pb IG2B 0.04359f
C294 I_MAG ICP2 0.07747f
C295 IG1B ain 0.08884f
C296 IG2A fs 0.04359f
C297 BWN BWK 0.01022f
C298 nb mip 0.07561f
C299 nb AFC4 0.03791f
C300 refck_a BWN 0.04285f
C301 B1 IG2B 0.04359f
C302 I_SIGN aqp 0.04457f
C303 aip IG2A 0.04427f
C304 I_MAG BWK 0.30396f
C305 AFC3 AFC5 0.12155f
C306 AFC1 BWN 1.54976f
C307 AFC7 AFC2 0.04359f
C308 mqn VCTRL 0.03676f
C309 vtn BWN 0.04359f
C310 B0 IG3A 0.04359f
C311 I_SIGN AFC0 0.04258f
C312 I_MAG AFC1 0.58485f
C313 min IG2B 0.08478f
C314 nb IG3A 0.05616f
C315 mip aqn 0.08718f
C316 pb IG1B 0.04427f
C317 BWN AFC5 0.03901f
C318 IG2A BWK 0.0364f
C319 mqn refck 0.03676f
C320 mqp l3n 0.03676f
C321 nb AFC7 0.04457f
C322 pb AFC6 0.03901f
C323 mqn l3p 0.03901f
C324 B1 IG1B 0.04427f
C325 AFC4 AFC3 4.33335f
C326 I_SIGN AFC2 0.04258f
C327 I_MAG AFC5 0.04322f
C328 aip IG1A 0.04425f
C329 vtn IG2A 0.04359f
C330 B0 IG2B 0.04359f
C331 aqn IG3A 0.04359f
C332 I_SIGN Q_SIGN 1.2669f
C333 AFC6 AFC0 0.03761f
C334 refck AFCOUT 0.04359f
C335 min IG1B 0.08223f
C336 nb IG2B 0.05616f
C337 mip BWN 0.04359f
C338 pb ain 0.04359f
C339 AFC4 BWN 0.03791f
C340 IG1A BWK 0.0364f
C341 pb refck 0.04359f
C342 mqp vctrl_i 0.03167f
C343 vctrl_i fs 0.00363f
C344 B1 ain 0.04457f
C345 AFC3 AFC7 0.04457f
C346 AFC4 I_MAG 0.18286f
C347 aip fs 0.04457f
C348 AFC6 AFC2 0.04322f
C349 min VCTRL 0.03676f
C350 fsb VSUBS 0.44457f ; **FLOATING
C351 Q_SIGN VSUBS 14.1738f
C352 AFC1 VSUBS 21.4806f
C353 AFC0 VSUBS 18.1584f
C354 aip VSUBS 44.4836f
C355 l3p VSUBS 9.35692f
C356 l4n VSUBS 5.2215f
C357 AFC6 VSUBS 13.4439f
C358 CLKOUT VSUBS 2.16071f ; **FLOATING
C359 I_SIGN VSUBS 27.511f
C360 I_MAG VSUBS 36.735f
C361 AFC7 VSUBS 16.483f
C362 AFC3 VSUBS 15.4714f
C363 AFC4 VSUBS 13.159f
C364 Q_MAG VSUBS 25.7927f
C365 AFC5 VSUBS 21.577f
C366 AFC2 VSUBS 27.0202f
C367 BWK VSUBS 45.5586f
C368 aqp VSUBS 65.2559f
C369 fs VSUBS 0.11445p
C370 ain VSUBS 46.4452f
C371 IG1A VSUBS 55.8362f
C372 IG1B VSUBS 56.9705f
C373 IG2A VSUBS 74.2341f
C374 IG2B VSUBS 79.294f
C375 BWN VSUBS 54.5244f
C376 IG3A VSUBS 81.0596f
C377 aqn VSUBS 69.8251f
C378 IG3B VSUBS 78.81879f
C379 B0 VSUBS 66.3817f
C380 vtn VSUBS 56.3371f
C381 ckr VSUBS 55.5622f
C382 ICP2 VSUBS 0.10782p
C383 refck_a VSUBS 74.9374f
C384 B1 VSUBS 67.6334f
C385 vctrl_i VSUBS 53.9678f
C386 refck VSUBS 81.7853f
C387 l3n VSUBS 11.41f
C388 l4p VSUBS 4.41818f ; **FLOATING
C389 l1n VSUBS 2.72599f ; **FLOATING
C390 l1p VSUBS 1.63103f ; **FLOATING
C391 l2n VSUBS 8.89345f
C392 l2p VSUBS 6.99668f
C393 vmon VSUBS 38.4202f
C394 mip VSUBS 89.4515f
C395 nb VSUBS 0.20281p
C396 rfp VSUBS 1.52551f
C397 min VSUBS 88.87679f
C398 rfn VSUBS 1.58472f
C399 pb VSUBS 0.12757p
C400 mqp VSUBS 52.0725f
C401 mqn VSUBS 51.4905f
C402 AFCOUT VSUBS 97.0752f
C403 REFIN VSUBS 41.1522f
C404 VCTRL VSUBS 21.0686f
C405 RFIN VSUBS 23.2161f
.ends
