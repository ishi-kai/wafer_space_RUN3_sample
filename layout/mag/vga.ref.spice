.subckt inv_dig A Y VDD VSS
XMN Y A VSS VSS nfet_03v3 L=0.28u W=1u nf=1  m=1
XMP Y A VDD VDD pfet_03v3 L=0.28u W=2u nf=1  m=1
.ends
.subckt vga INP INN GA GB NB PBV OUTP OUTN VDD VSS
XCC1 gp INP cap_mim_2f0_m4m5_noshield c_width=52.2e-6 c_length=52.2e-6 m=1
XCC2 gn INN cap_mim_2f0_m4m5_noshield c_width=52.2e-6 c_length=52.2e-6 m=1
XRB1 PBV gp VSS ppolyf_u_1k r_width=1u r_length=100u
XRB2 PBV gn VSS ppolyf_u_1k r_width=1u r_length=100u
XMT t NB VSS VSS nfet_03v3 L=2u W=32u nf=4  m=8
XM1 OUTN gp t VSS nfet_03v3 L=0.28u W=40u nf=8  m=1
XM2 OUTP gn t VSS nfet_03v3 L=0.28u W=40u nf=8  m=1
XMP0N OUTN OUTN VDD VDD pfet_03v3 L=0.56u W=24u nf=4  m=1
XMP0P OUTP OUTP VDD VDD pfet_03v3 L=0.56u W=24u nf=4  m=1
XGA GA gab VDD VSS inv_dig
XTGAN1 gan gab OUTN VSS nfet_03v3 L=0.28u W=2u nf=1  m=1
XTGAP1 gan GA OUTN VDD pfet_03v3 L=0.28u W=4u nf=1  m=1
XTGAN2 gan GA PBV VSS nfet_03v3 L=0.28u W=2u nf=1  m=1
XTGAP2 gan gab PBV VDD pfet_03v3 L=0.28u W=4u nf=1  m=1
XTGBN1 gap gab OUTP VSS nfet_03v3 L=0.28u W=2u nf=1  m=1
XTGBP1 gap GA OUTP VDD pfet_03v3 L=0.28u W=4u nf=1  m=1
XTGBN2 gap GA PBV VSS nfet_03v3 L=0.28u W=2u nf=1  m=1
XTGBP2 gap gab PBV VDD pfet_03v3 L=0.28u W=4u nf=1  m=1
XMPAN OUTN gan VDD VDD pfet_03v3 L=0.56u W=24u nf=4  m=1
XMPAP OUTP gap VDD VDD pfet_03v3 L=0.56u W=24u nf=4  m=1
XGB GB gbb VDD VSS inv_dig
XTGCN1 gbn gbb OUTN VSS nfet_03v3 L=0.28u W=2u nf=1  m=1
XTGCP1 gbn GB OUTN VDD pfet_03v3 L=0.28u W=4u nf=1  m=1
XTGCN2 gbn GB PBV VSS nfet_03v3 L=0.28u W=2u nf=1  m=1
XTGCP2 gbn gbb PBV VDD pfet_03v3 L=0.28u W=4u nf=1  m=1
XTGDN1 gbp gbb OUTP VSS nfet_03v3 L=0.28u W=2u nf=1  m=1
XTGDP1 gbp GB OUTP VDD pfet_03v3 L=0.28u W=4u nf=1  m=1
XTGDN2 gbp GB PBV VSS nfet_03v3 L=0.28u W=2u nf=1  m=1
XTGDP2 gbp gbb PBV VDD pfet_03v3 L=0.28u W=4u nf=1  m=1
XMPBN OUTN gbn VDD VDD pfet_03v3 L=0.56u W=48u nf=8  m=1
XMPBP OUTP gbp VDD VDD pfet_03v3 L=0.56u W=48u nf=8  m=1
.ends
