* NGSPICE file created from lna_nc_flat.ext - technology: gf180mcuD

.subckt lna_nc_flat VSS VDD RFIN PB OUTP OUTN
X0 a_7460_33166# RFIN cap_mim_2f0_m4m5_noshield c_width=5u c_length=5u
X1 a_7845_16440# a_7460_33166# VSS VSS nfet_03v3 ad=1.325p pd=5.53u as=1.325p ps=5.53u w=5u l=0.28u
X2 a_7845_16440# a_7460_33166# VSS VSS nfet_03v3 ad=1.325p pd=5.53u as=1.325p ps=5.53u w=5u l=0.28u
X3 OUTP a_1825_16440# cap_mim_2f0_m4m5_noshield c_width=5u c_length=5u
X4 OUTP a_1825_16440# cap_mim_2f0_m4m5_noshield c_width=5u c_length=5u
X5 OUTN a_7845_16440# cap_mim_2f0_m4m5_noshield c_width=5u c_length=5u
X6 VDD PB.t6 a_7460_31044.t2 VDD pfet_03v3 ad=2.12p pd=8.53u as=2.12p ps=8.53u w=8u l=2u
X7 OUTP a_1825_16440# cap_mim_2f0_m4m5_noshield c_width=5u c_length=5u
X8 a_7460_31044.t1 PB.t11 VDD VDD pfet_03v3 ad=2.12p pd=8.53u as=2.12p ps=8.53u w=8u l=2u
X9 a_7460_33166# RFIN cap_mim_2f0_m4m5_noshield c_width=5u c_length=5u
X10 a_7845_16440# a_7460_33166# VSS VSS nfet_03v3 ad=1.325p pd=5.53u as=1.325p ps=5.53u w=5u l=0.28u
X11 VSS a_7460_33166# a_7845_16440# VSS nfet_03v3 ad=1.325p pd=5.53u as=1.325p ps=5.53u w=5u l=0.28u
X12 OUTP a_1825_16440# cap_mim_2f0_m4m5_noshield c_width=5u c_length=5u
X13 VSS a_7460_33166# a_7845_16440# VSS nfet_03v3 ad=1.325p pd=5.53u as=1.325p ps=5.53u w=5u l=0.28u
X14 a_7845_16440# a_7460_33166# VSS VSS nfet_03v3 ad=1.325p pd=5.53u as=1.325p ps=5.53u w=5u l=0.28u
X15 a_7845_16440# a_7460_33166# VSS VSS nfet_03v3 ad=1.325p pd=5.53u as=1.325p ps=5.53u w=5u l=0.28u
X16 a_7460_31044.t0 PB.t29 VDD VDD pfet_03v3 ad=2.12p pd=8.53u as=2.12p ps=8.53u w=8u l=2u
X17 OUTP a_1825_16440# cap_mim_2f0_m4m5_noshield c_width=5u c_length=5u
X18 VDD PB.t2 a_7460_31044.t3 VDD pfet_03v3 ad=2.12p pd=8.53u as=2.12p ps=8.53u w=8u l=2u
X19 a_7845_16440# a_7460_33166# VSS VSS nfet_03v3 ad=1.325p pd=5.53u as=1.325p ps=5.53u w=5u l=0.28u
X20 a_7460_33166# RFIN cap_mim_2f0_m4m5_noshield c_width=5u c_length=5u
X21 a_7460_33166# RFIN cap_mim_2f0_m4m5_noshield c_width=5u c_length=5u
X22 OUTP a_1825_16440# cap_mim_2f0_m4m5_noshield c_width=5u c_length=5u
X23 a_7460_33166# RFIN cap_mim_2f0_m4m5_noshield c_width=5u c_length=5u
X24 OUTN a_7845_16440# cap_mim_2f0_m4m5_noshield c_width=5u c_length=5u
X25 OUTN a_7845_16440# cap_mim_2f0_m4m5_noshield c_width=5u c_length=5u
X26 OUTP a_1825_16440# cap_mim_2f0_m4m5_noshield c_width=5u c_length=5u
X27 a_7845_16440# a_7460_33166# VSS VSS nfet_03v3 ad=1.325p pd=5.53u as=1.325p ps=5.53u w=5u l=0.28u
X28 a_7460_31044.t1 PB.t19 VDD VDD pfet_03v3 ad=2.12p pd=8.53u as=2.12p ps=8.53u w=8u l=2u
X29 OUTN a_7845_16440# cap_mim_2f0_m4m5_noshield c_width=5u c_length=5u
X30 VSS a_7460_33166# a_7845_16440# VSS nfet_03v3 ad=1.325p pd=5.53u as=1.325p ps=5.53u w=5u l=0.28u
X31 VSS a_7460_33166# a_7845_16440# VSS nfet_03v3 ad=1.325p pd=5.53u as=1.325p ps=5.53u w=5u l=0.28u
X32 VSS a_7460_33166# a_7845_16440# VSS nfet_03v3 ad=2.225p pd=10.89u as=1.325p ps=5.53u w=5u l=0.28u
X33 VDD PB.t32 a_7460_31044.t0 VDD pfet_03v3 ad=2.12p pd=8.53u as=2.12p ps=8.53u w=8u l=2u
X34 a_7460_33166# RFIN cap_mim_2f0_m4m5_noshield c_width=5u c_length=5u
X35 a_7845_16440# a_7460_33166# VSS VSS nfet_03v3 ad=1.325p pd=5.53u as=1.325p ps=5.53u w=5u l=0.28u
X36 a_7460_33166# RFIN cap_mim_2f0_m4m5_noshield c_width=5u c_length=5u
X37 OUTP a_1825_16440# cap_mim_2f0_m4m5_noshield c_width=5u c_length=5u
X38 a_7460_33166# a_7460_31044.t0 VSS ppolyf_u_1k r_width=1u r_length=10u
X39 VSS a_7460_33166# a_7845_16440# VSS nfet_03v3 ad=2.225p pd=10.89u as=1.325p ps=5.53u w=5u l=0.28u
X40 OUTN a_7845_16440# cap_mim_2f0_m4m5_noshield c_width=5u c_length=5u
X41 a_7845_16440# a_7460_33166# VSS VSS nfet_03v3 ad=1.325p pd=5.53u as=1.325p ps=5.53u w=5u l=0.28u
X42 a_7845_16440# a_7460_33166# VSS VSS nfet_03v3 ad=1.325p pd=5.53u as=1.325p ps=5.53u w=5u l=0.28u
X43 OUTN a_7845_16440# cap_mim_2f0_m4m5_noshield c_width=5u c_length=5u
X44 a_7460_33166# RFIN cap_mim_2f0_m4m5_noshield c_width=5u c_length=5u
X45 a_7460_33166# RFIN cap_mim_2f0_m4m5_noshield c_width=5u c_length=5u
X46 a_7845_16440# a_7460_33166# VSS VSS nfet_03v3 ad=1.325p pd=5.53u as=1.325p ps=5.53u w=5u l=0.28u
X47 a_7460_33166# RFIN cap_mim_2f0_m4m5_noshield c_width=5u c_length=5u
X48 VSS a_7460_33166# a_7845_16440# VSS nfet_03v3 ad=1.325p pd=5.53u as=1.325p ps=5.53u w=5u l=0.28u
X49 OUTP a_1825_16440# cap_mim_2f0_m4m5_noshield c_width=5u c_length=5u
X50 OUTN a_7845_16440# cap_mim_2f0_m4m5_noshield c_width=5u c_length=5u
X51 VSS a_7460_33166# a_7845_16440# VSS nfet_03v3 ad=1.325p pd=5.53u as=1.325p ps=5.53u w=5u l=0.28u
X52 OUTN a_7845_16440# cap_mim_2f0_m4m5_noshield c_width=5u c_length=5u
X53 OUTN a_7845_16440# cap_mim_2f0_m4m5_noshield c_width=5u c_length=5u
X54 a_7460_33166# RFIN cap_mim_2f0_m4m5_noshield c_width=5u c_length=5u
X55 a_7845_16440# a_7460_33166# VSS VSS nfet_03v3 ad=1.325p pd=5.53u as=1.325p ps=5.53u w=5u l=0.28u
X56 OUTP a_1825_16440# cap_mim_2f0_m4m5_noshield c_width=5u c_length=5u
X57 OUTP a_1825_16440# cap_mim_2f0_m4m5_noshield c_width=5u c_length=5u
X58 a_7460_33166# RFIN cap_mim_2f0_m4m5_noshield c_width=5u c_length=5u
X59 OUTN a_7845_16440# cap_mim_2f0_m4m5_noshield c_width=5u c_length=5u
X60 a_7845_16440# a_7460_33166# VSS VSS nfet_03v3 ad=1.325p pd=5.53u as=1.325p ps=5.53u w=5u l=0.28u
X61 OUTN a_7845_16440# cap_mim_2f0_m4m5_noshield c_width=5u c_length=5u
X62 VDD PB.t14 a_7460_31044.t1 VDD pfet_03v3 ad=2.12p pd=8.53u as=2.12p ps=8.53u w=8u l=2u
X63 a_7460_33166# RFIN cap_mim_2f0_m4m5_noshield c_width=5u c_length=5u
X64 OUTP a_1825_16440# cap_mim_2f0_m4m5_noshield c_width=5u c_length=5u
X65 a_7845_16440# a_7460_33166# VSS VSS nfet_03v3 ad=1.325p pd=5.53u as=1.325p ps=5.53u w=5u l=0.28u
X66 OUTP a_1825_16440# cap_mim_2f0_m4m5_noshield c_width=5u c_length=5u
X67 OUTN a_7845_16440# cap_mim_2f0_m4m5_noshield c_width=5u c_length=5u
X68 OUTP a_1825_16440# cap_mim_2f0_m4m5_noshield c_width=5u c_length=5u
X69 OUTN a_7845_16440# cap_mim_2f0_m4m5_noshield c_width=5u c_length=5u
X70 OUTN a_7845_16440# cap_mim_2f0_m4m5_noshield c_width=5u c_length=5u
X71 a_7845_16440# a_7460_33166# VSS VSS nfet_03v3 ad=1.325p pd=5.53u as=1.325p ps=5.53u w=5u l=0.28u
X72 a_7460_33166# RFIN cap_mim_2f0_m4m5_noshield c_width=5u c_length=5u
X73 VSS a_7460_33166# a_7845_16440# VSS nfet_03v3 ad=1.325p pd=5.53u as=1.325p ps=5.53u w=5u l=0.28u
X74 a_1749_17589.t1 PB.t21 VDD VDD pfet_03v3 ad=2.12p pd=8.53u as=3.56p ps=16.89u w=8u l=2u
X75 a_7460_33166# RFIN cap_mim_2f0_m4m5_noshield c_width=5u c_length=5u
X76 VSS a_7460_33166# a_7845_16440# VSS nfet_03v3 ad=1.325p pd=5.53u as=1.325p ps=5.53u w=5u l=0.28u
X77 OUTP a_1825_16440# cap_mim_2f0_m4m5_noshield c_width=5u c_length=5u
X78 a_7460_33166# RFIN cap_mim_2f0_m4m5_noshield c_width=5u c_length=5u
X79 OUTP a_1825_16440# cap_mim_2f0_m4m5_noshield c_width=5u c_length=5u
X80 a_1749_17589.t0 PB.t27 VDD VDD pfet_03v3 ad=2.12p pd=8.53u as=2.12p ps=8.53u w=8u l=2u
X81 a_7845_16440# a_7460_33166# VSS VSS nfet_03v3 ad=1.325p pd=5.53u as=1.325p ps=5.53u w=5u l=0.28u
X82 VDD PB.t0 a_1749_17589.t4 VDD pfet_03v3 ad=3.56p pd=16.89u as=2.12p ps=8.53u w=8u l=2u
X83 VDD a_7845_16440# VSS ppolyf_u_1k r_width=30u r_length=2.17u
X84 OUTP a_1825_16440# cap_mim_2f0_m4m5_noshield c_width=5u c_length=5u
X85 a_7845_16440# a_7460_33166# VSS VSS nfet_03v3 ad=1.325p pd=5.53u as=1.325p ps=5.53u w=5u l=0.28u
X86 a_1749_17589.t1 PB.t17 VDD VDD pfet_03v3 ad=2.12p pd=8.53u as=2.12p ps=8.53u w=8u l=2u
X87 a_7460_33166# RFIN cap_mim_2f0_m4m5_noshield c_width=5u c_length=5u
X88 OUTP a_1825_16440# cap_mim_2f0_m4m5_noshield c_width=5u c_length=5u
X89 a_7460_33166# RFIN cap_mim_2f0_m4m5_noshield c_width=5u c_length=5u
X90 OUTP a_1825_16440# cap_mim_2f0_m4m5_noshield c_width=5u c_length=5u
X91 VSS a_7460_33166# a_7845_16440# VSS nfet_03v3 ad=1.325p pd=5.53u as=1.325p ps=5.53u w=5u l=0.28u
X92 VDD PB.t42 a_1749_17589.t0 VDD pfet_03v3 ad=2.12p pd=8.53u as=2.12p ps=8.53u w=8u l=2u
X93 OUTP a_1825_16440# cap_mim_2f0_m4m5_noshield c_width=5u c_length=5u
X94 RFIN a_1749_17589.t11 a_1825_16440# VSS nfet_03v3 ad=1.325p pd=5.53u as=1.325p ps=5.53u w=5u l=0.28u
X95 OUTN a_7845_16440# cap_mim_2f0_m4m5_noshield c_width=5u c_length=5u
X96 VSS a_7460_33166# a_7845_16440# VSS nfet_03v3 ad=1.325p pd=5.53u as=1.325p ps=5.53u w=5u l=0.28u
X97 a_7460_33166# RFIN cap_mim_2f0_m4m5_noshield c_width=5u c_length=5u
X98 a_7460_33166# RFIN cap_mim_2f0_m4m5_noshield c_width=5u c_length=5u
X99 a_7880_31766# VSS VSS ppolyf_u_1k r_width=1u r_length=3u
X100 a_7460_33166# RFIN cap_mim_2f0_m4m5_noshield c_width=5u c_length=5u
X101 a_7460_33166# RFIN cap_mim_2f0_m4m5_noshield c_width=5u c_length=5u
X102 OUTP a_1825_16440# cap_mim_2f0_m4m5_noshield c_width=5u c_length=5u
X103 OUTN a_7845_16440# cap_mim_2f0_m4m5_noshield c_width=5u c_length=5u
X104 OUTN a_7845_16440# cap_mim_2f0_m4m5_noshield c_width=5u c_length=5u
X105 a_7845_16440# a_7460_33166# VSS VSS nfet_03v3 ad=1.325p pd=5.53u as=1.325p ps=5.53u w=5u l=0.28u
X106 a_7460_33166# RFIN cap_mim_2f0_m4m5_noshield c_width=5u c_length=5u
X107 OUTP a_1825_16440# cap_mim_2f0_m4m5_noshield c_width=5u c_length=5u
X108 a_1749_17589.t2 PB.t9 VDD VDD pfet_03v3 ad=2.12p pd=8.53u as=2.12p ps=8.53u w=8u l=2u
X109 VDD PB.t16 a_1749_17589.t1 VDD pfet_03v3 ad=2.12p pd=8.53u as=2.12p ps=8.53u w=8u l=2u
X110 a_7460_33166# RFIN cap_mim_2f0_m4m5_noshield c_width=5u c_length=5u
X111 a_7845_16440# a_7460_33166# VSS VSS nfet_03v3 ad=1.325p pd=5.53u as=1.325p ps=5.53u w=5u l=0.28u
X112 OUTN a_7845_16440# cap_mim_2f0_m4m5_noshield c_width=5u c_length=5u
X113 RFIN a_1749_17589.t9 a_1825_16440# VSS nfet_03v3 ad=2.225p pd=10.89u as=1.325p ps=5.53u w=5u l=0.28u
X114 OUTN a_7845_16440# cap_mim_2f0_m4m5_noshield c_width=5u c_length=5u
X115 VSS a_7460_33166# a_7845_16440# VSS nfet_03v3 ad=1.325p pd=5.53u as=1.325p ps=5.53u w=5u l=0.28u
X116 OUTN a_7845_16440# cap_mim_2f0_m4m5_noshield c_width=5u c_length=5u
X117 OUTN a_7845_16440# cap_mim_2f0_m4m5_noshield c_width=5u c_length=5u
X118 VSS a_7460_33166# a_7845_16440# VSS nfet_03v3 ad=1.325p pd=5.53u as=1.325p ps=5.53u w=5u l=0.28u
X119 VDD PB.t12 a_1749_17589.t2 VDD pfet_03v3 ad=2.12p pd=8.53u as=2.12p ps=8.53u w=8u l=2u
X120 OUTP a_1825_16440# cap_mim_2f0_m4m5_noshield c_width=5u c_length=5u
X121 a_7460_33166# RFIN cap_mim_2f0_m4m5_noshield c_width=5u c_length=5u
X122 a_7460_33166# RFIN cap_mim_2f0_m4m5_noshield c_width=5u c_length=5u
X123 OUTP a_1825_16440# cap_mim_2f0_m4m5_noshield c_width=5u c_length=5u
X124 OUTP a_1825_16440# cap_mim_2f0_m4m5_noshield c_width=5u c_length=5u
X125 a_1825_16440# a_1749_17589.t30 RFIN VSS nfet_03v3 ad=1.325p pd=5.53u as=1.325p ps=5.53u w=5u l=0.28u
X126 OUTN a_7845_16440# cap_mim_2f0_m4m5_noshield c_width=5u c_length=5u
X127 OUTN a_7845_16440# cap_mim_2f0_m4m5_noshield c_width=5u c_length=5u
X128 a_7460_33166# RFIN cap_mim_2f0_m4m5_noshield c_width=5u c_length=5u
X129 a_1825_16440# a_1749_17589.t16 RFIN VSS nfet_03v3 ad=1.325p pd=5.53u as=1.325p ps=5.53u w=5u l=0.28u
X130 OUTP a_1825_16440# cap_mim_2f0_m4m5_noshield c_width=5u c_length=5u
X131 OUTP a_1825_16440# cap_mim_2f0_m4m5_noshield c_width=5u c_length=5u
X132 a_7460_31044.t0 PB.t25 VDD VDD pfet_03v3 ad=2.12p pd=8.53u as=2.12p ps=8.53u w=8u l=2u
X133 OUTN a_7845_16440# cap_mim_2f0_m4m5_noshield c_width=5u c_length=5u
X134 a_7460_33166# RFIN cap_mim_2f0_m4m5_noshield c_width=5u c_length=5u
X135 a_7460_33166# RFIN cap_mim_2f0_m4m5_noshield c_width=5u c_length=5u
X136 OUTP a_1825_16440# cap_mim_2f0_m4m5_noshield c_width=5u c_length=5u
X137 OUTP a_1825_16440# cap_mim_2f0_m4m5_noshield c_width=5u c_length=5u
X138 a_1825_16440# a_1749_17589.t14 RFIN VSS nfet_03v3 ad=1.325p pd=5.53u as=1.325p ps=5.53u w=5u l=0.28u
X139 VDD PB.t40 a_7460_31044.t0 VDD pfet_03v3 ad=2.12p pd=8.53u as=2.12p ps=8.53u w=8u l=2u
X140 a_7460_33166# RFIN cap_mim_2f0_m4m5_noshield c_width=5u c_length=5u
X141 RFIN a_1749_17589.t17 a_1825_16440# VSS nfet_03v3 ad=1.325p pd=5.53u as=1.325p ps=5.53u w=5u l=0.28u
X142 OUTN a_7845_16440# cap_mim_2f0_m4m5_noshield c_width=5u c_length=5u
X143 a_7460_33166# RFIN cap_mim_2f0_m4m5_noshield c_width=5u c_length=5u
X144 OUTP a_1825_16440# cap_mim_2f0_m4m5_noshield c_width=5u c_length=5u
X145 OUTP a_1825_16440# cap_mim_2f0_m4m5_noshield c_width=5u c_length=5u
X146 OUTN a_7845_16440# cap_mim_2f0_m4m5_noshield c_width=5u c_length=5u
X147 RFIN a_1749_17589.t21 a_1825_16440# VSS nfet_03v3 ad=1.325p pd=5.53u as=1.325p ps=5.53u w=5u l=0.28u
X148 a_7460_33166# RFIN cap_mim_2f0_m4m5_noshield c_width=5u c_length=5u
X149 a_7460_31044.t2 PB.t7 VDD VDD pfet_03v3 ad=2.12p pd=8.53u as=2.12p ps=8.53u w=8u l=2u
X150 OUTP a_1825_16440# cap_mim_2f0_m4m5_noshield c_width=5u c_length=5u
X151 a_7460_33166# RFIN cap_mim_2f0_m4m5_noshield c_width=5u c_length=5u
X152 OUTP a_1825_16440# cap_mim_2f0_m4m5_noshield c_width=5u c_length=5u
X153 a_7460_33166# RFIN cap_mim_2f0_m4m5_noshield c_width=5u c_length=5u
X154 OUTN a_7845_16440# cap_mim_2f0_m4m5_noshield c_width=5u c_length=5u
X155 OUTN a_7845_16440# cap_mim_2f0_m4m5_noshield c_width=5u c_length=5u
X156 OUTP a_1825_16440# cap_mim_2f0_m4m5_noshield c_width=5u c_length=5u
X157 a_1825_16440# a_1749_17589.t24 RFIN VSS nfet_03v3 ad=1.325p pd=5.53u as=1.325p ps=5.53u w=5u l=0.28u
X158 OUTN a_7845_16440# cap_mim_2f0_m4m5_noshield c_width=5u c_length=5u
X159 a_7880_31766# a_1749_17589.t5 a_1749_17589.t6 VSS nfet_03v3 ad=2.67p pd=12.89u as=1.59p ps=6.53u w=6u l=0.28u
X160 a_1825_16440# a_1749_17589.t10 RFIN VSS nfet_03v3 ad=1.325p pd=5.53u as=1.325p ps=5.53u w=5u l=0.28u
X161 a_7460_31044.t0 PB.t37 VDD VDD pfet_03v3 ad=2.12p pd=8.53u as=2.12p ps=8.53u w=8u l=2u
X162 VDD PB.t10 a_7460_31044.t1 VDD pfet_03v3 ad=2.12p pd=8.53u as=2.12p ps=8.53u w=8u l=2u
X163 OUTP a_1825_16440# cap_mim_2f0_m4m5_noshield c_width=5u c_length=5u
X164 a_7460_33166# RFIN cap_mim_2f0_m4m5_noshield c_width=5u c_length=5u
X165 OUTN a_7845_16440# cap_mim_2f0_m4m5_noshield c_width=5u c_length=5u
X166 OUTN a_7845_16440# cap_mim_2f0_m4m5_noshield c_width=5u c_length=5u
X167 OUTP a_1825_16440# cap_mim_2f0_m4m5_noshield c_width=5u c_length=5u
X168 RFIN a_1749_17589.t19 a_1825_16440# VSS nfet_03v3 ad=1.325p pd=5.53u as=1.325p ps=5.53u w=5u l=0.28u
X169 a_7460_33166# RFIN cap_mim_2f0_m4m5_noshield c_width=5u c_length=5u
X170 OUTN a_7845_16440# cap_mim_2f0_m4m5_noshield c_width=5u c_length=5u
X171 a_7460_33166# RFIN cap_mim_2f0_m4m5_noshield c_width=5u c_length=5u
X172 a_7460_33166# RFIN cap_mim_2f0_m4m5_noshield c_width=5u c_length=5u
X173 OUTP a_1825_16440# cap_mim_2f0_m4m5_noshield c_width=5u c_length=5u
X174 a_1825_16440# a_1749_17589.t22 RFIN VSS nfet_03v3 ad=1.325p pd=5.53u as=1.325p ps=5.53u w=5u l=0.28u
X175 OUTP a_1825_16440# cap_mim_2f0_m4m5_noshield c_width=5u c_length=5u
X176 a_1749_17589.t0 PB.t23 VDD VDD pfet_03v3 ad=2.12p pd=8.53u as=2.12p ps=8.53u w=8u l=2u
X177 a_7460_33166# RFIN cap_mim_2f0_m4m5_noshield c_width=5u c_length=5u
X178 a_1749_17589.t8 VSS cap_mim_2f0_m4m5_noshield c_width=50u c_length=50u
X179 OUTN a_7845_16440# cap_mim_2f0_m4m5_noshield c_width=5u c_length=5u
X180 OUTN a_7845_16440# cap_mim_2f0_m4m5_noshield c_width=5u c_length=5u
X181 a_7460_33166# RFIN cap_mim_2f0_m4m5_noshield c_width=5u c_length=5u
X182 OUTN a_7845_16440# cap_mim_2f0_m4m5_noshield c_width=5u c_length=5u
X183 a_1825_16440# a_1749_17589.t26 RFIN VSS nfet_03v3 ad=1.325p pd=5.53u as=1.325p ps=5.53u w=5u l=0.28u
X184 OUTP a_1825_16440# cap_mim_2f0_m4m5_noshield c_width=5u c_length=5u
X185 OUTP a_1825_16440# cap_mim_2f0_m4m5_noshield c_width=5u c_length=5u
X186 OUTP a_1825_16440# cap_mim_2f0_m4m5_noshield c_width=5u c_length=5u
X187 a_7460_33166# RFIN cap_mim_2f0_m4m5_noshield c_width=5u c_length=5u
X188 RFIN a_1749_17589.t29 a_1825_16440# VSS nfet_03v3 ad=1.325p pd=5.53u as=1.325p ps=5.53u w=5u l=0.28u
X189 a_7460_33166# RFIN cap_mim_2f0_m4m5_noshield c_width=5u c_length=5u
X190 VSS a_7460_31044.t4 a_7460_31044.t5 VSS nfet_03v3 ad=1.78p pd=8.89u as=1.06p ps=4.53u w=4u l=0.28u
X191 OUTN a_7845_16440# cap_mim_2f0_m4m5_noshield c_width=5u c_length=5u
X192 RFIN a_1749_17589.t15 a_1825_16440# VSS nfet_03v3 ad=1.325p pd=5.53u as=1.325p ps=5.53u w=5u l=0.28u
X193 a_7460_33166# RFIN cap_mim_2f0_m4m5_noshield c_width=5u c_length=5u
X194 OUTP a_1825_16440# cap_mim_2f0_m4m5_noshield c_width=5u c_length=5u
X195 OUTN a_7845_16440# cap_mim_2f0_m4m5_noshield c_width=5u c_length=5u
X196 OUTP a_1825_16440# cap_mim_2f0_m4m5_noshield c_width=5u c_length=5u
X197 OUTP a_1825_16440# cap_mim_2f0_m4m5_noshield c_width=5u c_length=5u
X198 OUTN a_7845_16440# cap_mim_2f0_m4m5_noshield c_width=5u c_length=5u
X199 a_7460_33166# RFIN cap_mim_2f0_m4m5_noshield c_width=5u c_length=5u
X200 OUTN a_7845_16440# cap_mim_2f0_m4m5_noshield c_width=5u c_length=5u
X201 OUTP a_1825_16440# cap_mim_2f0_m4m5_noshield c_width=5u c_length=5u
X202 a_1825_16440# a_1749_17589.t18 RFIN VSS nfet_03v3 ad=1.325p pd=5.53u as=1.325p ps=5.53u w=5u l=0.28u
X203 a_7460_31044.t7 VSS cap_mim_2f0_m4m5_noshield c_width=50u c_length=50u
X204 a_7460_33166# RFIN cap_mim_2f0_m4m5_noshield c_width=5u c_length=5u
X205 OUTP a_1825_16440# cap_mim_2f0_m4m5_noshield c_width=5u c_length=5u
X206 OUTN a_7845_16440# cap_mim_2f0_m4m5_noshield c_width=5u c_length=5u
X207 a_1749_17589.t3 PB.t5 VDD VDD pfet_03v3 ad=2.12p pd=8.53u as=2.12p ps=8.53u w=8u l=2u
X208 OUTP a_1825_16440# cap_mim_2f0_m4m5_noshield c_width=5u c_length=5u
X209 RFIN a_1749_17589.t27 a_1825_16440# VSS nfet_03v3 ad=1.325p pd=5.53u as=1.325p ps=5.53u w=5u l=0.28u
X210 OUTP a_1825_16440# cap_mim_2f0_m4m5_noshield c_width=5u c_length=5u
X211 OUTN a_7845_16440# cap_mim_2f0_m4m5_noshield c_width=5u c_length=5u
X212 RFIN a_1749_17589.t13 a_1825_16440# VSS nfet_03v3 ad=1.325p pd=5.53u as=1.325p ps=5.53u w=5u l=0.28u
X213 a_7460_33166# RFIN cap_mim_2f0_m4m5_noshield c_width=5u c_length=5u
X214 OUTP a_1825_16440# cap_mim_2f0_m4m5_noshield c_width=5u c_length=5u
X215 OUTP a_1825_16440# cap_mim_2f0_m4m5_noshield c_width=5u c_length=5u
X216 VDD PB.t30 a_1749_17589.t0 VDD pfet_03v3 ad=2.12p pd=8.53u as=2.12p ps=8.53u w=8u l=2u
X217 a_1749_17589.t0 PB.t35 VDD VDD pfet_03v3 ad=2.12p pd=8.53u as=2.12p ps=8.53u w=8u l=2u
X218 RFIN a_1749_17589.t31 a_1825_16440# VSS nfet_03v3 ad=1.325p pd=5.53u as=1.325p ps=5.53u w=5u l=0.28u
X219 OUTP a_1825_16440# cap_mim_2f0_m4m5_noshield c_width=5u c_length=5u
X220 VDD PB.t20 a_1749_17589.t1 VDD pfet_03v3 ad=2.12p pd=8.53u as=2.12p ps=8.53u w=8u l=2u
X221 OUTN a_7845_16440# cap_mim_2f0_m4m5_noshield c_width=5u c_length=5u
X222 OUTN a_7845_16440# cap_mim_2f0_m4m5_noshield c_width=5u c_length=5u
X223 a_7460_33166# RFIN cap_mim_2f0_m4m5_noshield c_width=5u c_length=5u
X224 VDD PB.t26 a_1749_17589.t0 VDD pfet_03v3 ad=2.12p pd=8.53u as=2.12p ps=8.53u w=8u l=2u
X225 a_7460_33166# RFIN cap_mim_2f0_m4m5_noshield c_width=5u c_length=5u
X226 OUTP a_1825_16440# cap_mim_2f0_m4m5_noshield c_width=5u c_length=5u
X227 a_7460_33166# RFIN cap_mim_2f0_m4m5_noshield c_width=5u c_length=5u
X228 a_1825_16440# a_1749_17589.t20 RFIN VSS nfet_03v3 ad=1.325p pd=5.53u as=1.325p ps=5.53u w=5u l=0.28u
X229 OUTN a_7845_16440# cap_mim_2f0_m4m5_noshield c_width=5u c_length=5u
X230 OUTN a_7845_16440# cap_mim_2f0_m4m5_noshield c_width=5u c_length=5u
X231 RFIN a_1749_17589.t23 a_1825_16440# VSS nfet_03v3 ad=1.325p pd=5.53u as=1.325p ps=5.53u w=5u l=0.28u
X232 a_7460_33166# RFIN cap_mim_2f0_m4m5_noshield c_width=5u c_length=5u
X233 OUTN a_7845_16440# cap_mim_2f0_m4m5_noshield c_width=5u c_length=5u
X234 OUTN a_7845_16440# cap_mim_2f0_m4m5_noshield c_width=5u c_length=5u
X235 OUTP a_1825_16440# cap_mim_2f0_m4m5_noshield c_width=5u c_length=5u
X236 a_1825_16440# a_1749_17589.t32 RFIN VSS nfet_03v3 ad=1.325p pd=5.53u as=2.225p ps=10.89u w=5u l=0.28u
X237 OUTN a_7845_16440# cap_mim_2f0_m4m5_noshield c_width=5u c_length=5u
X238 a_1825_16440# a_1749_17589.t12 RFIN VSS nfet_03v3 ad=1.325p pd=5.53u as=1.325p ps=5.53u w=5u l=0.28u
X239 a_7460_33166# RFIN cap_mim_2f0_m4m5_noshield c_width=5u c_length=5u
X240 OUTP a_1825_16440# cap_mim_2f0_m4m5_noshield c_width=5u c_length=5u
X241 OUTN a_7845_16440# cap_mim_2f0_m4m5_noshield c_width=5u c_length=5u
X242 OUTP a_1825_16440# cap_mim_2f0_m4m5_noshield c_width=5u c_length=5u
X243 OUTN a_7845_16440# cap_mim_2f0_m4m5_noshield c_width=5u c_length=5u
X244 a_7460_33166# RFIN cap_mim_2f0_m4m5_noshield c_width=5u c_length=5u
X245 OUTP a_1825_16440# cap_mim_2f0_m4m5_noshield c_width=5u c_length=5u
X246 OUTN a_7845_16440# cap_mim_2f0_m4m5_noshield c_width=5u c_length=5u
X247 RFIN a_1749_17589.t25 a_1825_16440# VSS nfet_03v3 ad=1.325p pd=5.53u as=1.325p ps=5.53u w=5u l=0.28u
X248 a_7460_31044.t3 PB.t3 VDD VDD pfet_03v3 ad=2.12p pd=8.53u as=2.12p ps=8.53u w=8u l=2u
X249 a_7460_33166# RFIN cap_mim_2f0_m4m5_noshield c_width=5u c_length=5u
X250 OUTN a_7845_16440# cap_mim_2f0_m4m5_noshield c_width=5u c_length=5u
X251 OUTP a_1825_16440# cap_mim_2f0_m4m5_noshield c_width=5u c_length=5u
X252 a_1825_16440# a_1749_17589.t28 RFIN VSS nfet_03v3 ad=1.325p pd=5.53u as=1.325p ps=5.53u w=5u l=0.28u
X253 VDD PB.t28 a_7460_31044.t0 VDD pfet_03v3 ad=2.12p pd=8.53u as=2.12p ps=8.53u w=8u l=2u
X254 OUTN a_7845_16440# cap_mim_2f0_m4m5_noshield c_width=5u c_length=5u
X255 a_7460_31044.t0 PB.t33 VDD VDD pfet_03v3 ad=2.12p pd=8.53u as=2.12p ps=8.53u w=8u l=2u
X256 a_7460_33166# RFIN cap_mim_2f0_m4m5_noshield c_width=5u c_length=5u
X257 OUTN a_7845_16440# cap_mim_2f0_m4m5_noshield c_width=5u c_length=5u
X258 OUTP a_1825_16440# cap_mim_2f0_m4m5_noshield c_width=5u c_length=5u
X259 OUTN a_7845_16440# cap_mim_2f0_m4m5_noshield c_width=5u c_length=5u
X260 VDD PB.t18 a_7460_31044.t1 VDD pfet_03v3 ad=2.12p pd=8.53u as=2.12p ps=8.53u w=8u l=2u
X261 VDD PB.t24 a_7460_31044.t0 VDD pfet_03v3 ad=2.12p pd=8.53u as=2.12p ps=8.53u w=8u l=2u
X262 a_7460_33166# RFIN cap_mim_2f0_m4m5_noshield c_width=5u c_length=5u
X263 a_7460_33166# RFIN cap_mim_2f0_m4m5_noshield c_width=5u c_length=5u
X264 OUTP a_1825_16440# cap_mim_2f0_m4m5_noshield c_width=5u c_length=5u
X265 OUTP a_1825_16440# cap_mim_2f0_m4m5_noshield c_width=5u c_length=5u
X266 a_7460_31044.t0 PB.t41 VDD VDD pfet_03v3 ad=2.12p pd=8.53u as=2.12p ps=8.53u w=8u l=2u
X267 OUTN a_7845_16440# cap_mim_2f0_m4m5_noshield c_width=5u c_length=5u
X268 a_7460_33166# RFIN cap_mim_2f0_m4m5_noshield c_width=5u c_length=5u
X269 OUTN a_7845_16440# cap_mim_2f0_m4m5_noshield c_width=5u c_length=5u
X270 OUTP a_1825_16440# cap_mim_2f0_m4m5_noshield c_width=5u c_length=5u
X271 a_7460_33166# RFIN cap_mim_2f0_m4m5_noshield c_width=5u c_length=5u
X272 a_7460_33166# RFIN cap_mim_2f0_m4m5_noshield c_width=5u c_length=5u
X273 OUTP a_1825_16440# cap_mim_2f0_m4m5_noshield c_width=5u c_length=5u
X274 OUTP a_1825_16440# cap_mim_2f0_m4m5_noshield c_width=5u c_length=5u
X275 OUTN a_7845_16440# cap_mim_2f0_m4m5_noshield c_width=5u c_length=5u
X276 a_7460_33166# RFIN cap_mim_2f0_m4m5_noshield c_width=5u c_length=5u
X277 OUTN a_7845_16440# cap_mim_2f0_m4m5_noshield c_width=5u c_length=5u
X278 a_7460_33166# RFIN cap_mim_2f0_m4m5_noshield c_width=5u c_length=5u
X279 VSS a_7460_33166# a_7845_16440# VSS nfet_03v3 ad=1.325p pd=5.53u as=1.325p ps=5.53u w=5u l=0.28u
X280 OUTP a_1825_16440# cap_mim_2f0_m4m5_noshield c_width=5u c_length=5u
X281 a_7460_31044.t1 PB.t15 VDD VDD pfet_03v3 ad=2.12p pd=8.53u as=2.12p ps=8.53u w=8u l=2u
X282 OUTN a_7845_16440# cap_mim_2f0_m4m5_noshield c_width=5u c_length=5u
X283 a_7460_33166# RFIN cap_mim_2f0_m4m5_noshield c_width=5u c_length=5u
X284 OUTN a_7845_16440# cap_mim_2f0_m4m5_noshield c_width=5u c_length=5u
X285 VSS a_7460_33166# a_7845_16440# VSS nfet_03v3 ad=1.325p pd=5.53u as=1.325p ps=5.53u w=5u l=0.28u
X286 OUTP a_1825_16440# cap_mim_2f0_m4m5_noshield c_width=5u c_length=5u
X287 OUTP a_1825_16440# cap_mim_2f0_m4m5_noshield c_width=5u c_length=5u
X288 a_7845_16440# a_7460_33166# VSS VSS nfet_03v3 ad=1.325p pd=5.53u as=1.325p ps=5.53u w=5u l=0.28u
X289 a_7460_33166# RFIN cap_mim_2f0_m4m5_noshield c_width=5u c_length=5u
X290 OUTN a_7845_16440# cap_mim_2f0_m4m5_noshield c_width=5u c_length=5u
X291 a_7845_16440# a_7460_33166# VSS VSS nfet_03v3 ad=1.325p pd=5.53u as=1.325p ps=5.53u w=5u l=0.28u
X292 a_7460_33166# RFIN cap_mim_2f0_m4m5_noshield c_width=5u c_length=5u
X293 VSS a_7460_33166# a_7845_16440# VSS nfet_03v3 ad=1.325p pd=5.53u as=1.325p ps=5.53u w=5u l=0.28u
X294 OUTN a_7845_16440# cap_mim_2f0_m4m5_noshield c_width=5u c_length=5u
X295 OUTN a_7845_16440# cap_mim_2f0_m4m5_noshield c_width=5u c_length=5u
X296 OUTN a_7845_16440# cap_mim_2f0_m4m5_noshield c_width=5u c_length=5u
X297 OUTP a_1825_16440# cap_mim_2f0_m4m5_noshield c_width=5u c_length=5u
X298 VSS a_7460_33166# a_7845_16440# VSS nfet_03v3 ad=1.325p pd=5.53u as=1.325p ps=5.53u w=5u l=0.28u
X299 OUTN a_7845_16440# cap_mim_2f0_m4m5_noshield c_width=5u c_length=5u
X300 a_7460_33166# RFIN cap_mim_2f0_m4m5_noshield c_width=5u c_length=5u
X301 a_1749_17589.t4 PB.t1 VDD VDD pfet_03v3 ad=2.12p pd=8.53u as=2.12p ps=8.53u w=8u l=2u
X302 VDD PB.t36 a_7460_31044.t0 VDD pfet_03v3 ad=2.12p pd=8.53u as=2.12p ps=8.53u w=8u l=2u
X303 OUTN a_7845_16440# cap_mim_2f0_m4m5_noshield c_width=5u c_length=5u
X304 VSS a_7460_33166# a_7845_16440# VSS nfet_03v3 ad=1.325p pd=5.53u as=1.325p ps=5.53u w=5u l=0.28u
X305 a_7460_33166# RFIN cap_mim_2f0_m4m5_noshield c_width=5u c_length=5u
X306 a_1749_17589.t6 a_1749_17589.t5 a_7880_31766# VSS nfet_03v3 ad=1.59p pd=6.53u as=2.67p ps=12.89u w=6u l=0.28u
X307 VSS a_7460_33166# a_7845_16440# VSS nfet_03v3 ad=1.325p pd=5.53u as=1.325p ps=5.53u w=5u l=0.28u
X308 OUTP a_1825_16440# cap_mim_2f0_m4m5_noshield c_width=5u c_length=5u
X309 OUTP a_1825_16440# cap_mim_2f0_m4m5_noshield c_width=5u c_length=5u
X310 OUTP a_1825_16440# cap_mim_2f0_m4m5_noshield c_width=5u c_length=5u
X311 OUTN a_7845_16440# cap_mim_2f0_m4m5_noshield c_width=5u c_length=5u
X312 VSS RFIN VSS ppolyf_u_1k r_width=10u r_length=3u
X313 a_7460_33166# RFIN cap_mim_2f0_m4m5_noshield c_width=5u c_length=5u
X314 OUTN a_7845_16440# cap_mim_2f0_m4m5_noshield c_width=5u c_length=5u
X315 a_1749_17589.t0 PB.t43 VDD VDD pfet_03v3 ad=2.12p pd=8.53u as=3.56p ps=16.89u w=8u l=2u
X316 OUTP a_1825_16440# cap_mim_2f0_m4m5_noshield c_width=5u c_length=5u
X317 OUTP a_1825_16440# cap_mim_2f0_m4m5_noshield c_width=5u c_length=5u
X318 a_7845_16440# a_7460_33166# VSS VSS nfet_03v3 ad=1.325p pd=5.53u as=1.325p ps=5.53u w=5u l=0.28u
X319 VDD PB.t22 a_1749_17589.t0 VDD pfet_03v3 ad=3.56p pd=16.89u as=2.12p ps=8.53u w=8u l=2u
X320 a_7460_33166# RFIN cap_mim_2f0_m4m5_noshield c_width=5u c_length=5u
X321 OUTN a_7845_16440# cap_mim_2f0_m4m5_noshield c_width=5u c_length=5u
X322 a_7845_16440# a_7460_33166# VSS VSS nfet_03v3 ad=1.325p pd=5.53u as=1.325p ps=5.53u w=5u l=0.28u
X323 a_1749_17589.t0 PB.t39 VDD VDD pfet_03v3 ad=2.12p pd=8.53u as=2.12p ps=8.53u w=8u l=2u
X324 OUTN a_7845_16440# cap_mim_2f0_m4m5_noshield c_width=5u c_length=5u
X325 VSS a_7460_33166# a_7845_16440# VSS nfet_03v3 ad=1.325p pd=5.53u as=1.325p ps=5.53u w=5u l=0.28u
X326 a_7460_33166# RFIN cap_mim_2f0_m4m5_noshield c_width=5u c_length=5u
X327 VSS a_7460_33166# a_7845_16440# VSS nfet_03v3 ad=1.325p pd=5.53u as=1.325p ps=5.53u w=5u l=0.28u
X328 OUTP a_1825_16440# cap_mim_2f0_m4m5_noshield c_width=5u c_length=5u
X329 a_7845_16440# a_7460_33166# VSS VSS nfet_03v3 ad=1.325p pd=5.53u as=1.325p ps=5.53u w=5u l=0.28u
X330 OUTP a_1825_16440# cap_mim_2f0_m4m5_noshield c_width=5u c_length=5u
X331 OUTP a_1825_16440# cap_mim_2f0_m4m5_noshield c_width=5u c_length=5u
X332 a_7845_16440# a_7460_33166# VSS VSS nfet_03v3 ad=1.325p pd=5.53u as=1.325p ps=5.53u w=5u l=0.28u
X333 a_7460_33166# RFIN cap_mim_2f0_m4m5_noshield c_width=5u c_length=5u
X334 OUTN a_7845_16440# cap_mim_2f0_m4m5_noshield c_width=5u c_length=5u
X335 a_7460_31044.t5 a_7460_31044.t4 VSS VSS nfet_03v3 ad=1.06p pd=4.53u as=1.78p ps=8.89u w=4u l=0.28u
X336 VDD PB.t8 a_1749_17589.t2 VDD pfet_03v3 ad=2.12p pd=8.53u as=2.12p ps=8.53u w=8u l=2u
X337 VSS a_7460_33166# a_7845_16440# VSS nfet_03v3 ad=1.325p pd=5.53u as=1.325p ps=5.53u w=5u l=0.28u
X338 a_1749_17589.t2 PB.t13 VDD VDD pfet_03v3 ad=2.12p pd=8.53u as=2.12p ps=8.53u w=8u l=2u
X339 a_7460_33166# RFIN cap_mim_2f0_m4m5_noshield c_width=5u c_length=5u
X340 OUTP a_1825_16440# cap_mim_2f0_m4m5_noshield c_width=5u c_length=5u
X341 OUTN a_7845_16440# cap_mim_2f0_m4m5_noshield c_width=5u c_length=5u
X342 VSS a_7460_33166# a_7845_16440# VSS nfet_03v3 ad=1.325p pd=5.53u as=1.325p ps=5.53u w=5u l=0.28u
X343 OUTN a_7845_16440# cap_mim_2f0_m4m5_noshield c_width=5u c_length=5u
X344 VSS a_7460_33166# a_7845_16440# VSS nfet_03v3 ad=1.325p pd=5.53u as=1.325p ps=5.53u w=5u l=0.28u
X345 VSS a_7460_33166# a_7845_16440# VSS nfet_03v3 ad=1.325p pd=5.53u as=1.325p ps=5.53u w=5u l=0.28u
X346 a_1749_17589.t0 PB.t31 VDD VDD pfet_03v3 ad=2.12p pd=8.53u as=2.12p ps=8.53u w=8u l=2u
X347 a_7460_33166# RFIN cap_mim_2f0_m4m5_noshield c_width=5u c_length=5u
X348 a_7460_33166# RFIN cap_mim_2f0_m4m5_noshield c_width=5u c_length=5u
X349 VDD PB.t4 a_1749_17589.t3 VDD pfet_03v3 ad=2.12p pd=8.53u as=2.12p ps=8.53u w=8u l=2u
X350 OUTP a_1825_16440# cap_mim_2f0_m4m5_noshield c_width=5u c_length=5u
X351 VDD PB.t38 a_1749_17589.t0 VDD pfet_03v3 ad=2.12p pd=8.53u as=2.12p ps=8.53u w=8u l=2u
X352 OUTP a_1825_16440# cap_mim_2f0_m4m5_noshield c_width=5u c_length=5u
X353 VSS a_7460_33166# a_7845_16440# VSS nfet_03v3 ad=1.325p pd=5.53u as=1.325p ps=5.53u w=5u l=0.28u
X354 OUTN a_7845_16440# cap_mim_2f0_m4m5_noshield c_width=5u c_length=5u
X355 VSS a_7460_33166# a_7845_16440# VSS nfet_03v3 ad=1.325p pd=5.53u as=1.325p ps=5.53u w=5u l=0.28u
X356 a_7460_33166# RFIN cap_mim_2f0_m4m5_noshield c_width=5u c_length=5u
X357 VDD PB.t34 a_1749_17589.t0 VDD pfet_03v3 ad=2.12p pd=8.53u as=2.12p ps=8.53u w=8u l=2u
X358 VSS a_7460_33166# a_7845_16440# VSS nfet_03v3 ad=1.325p pd=5.53u as=1.325p ps=5.53u w=5u l=0.28u
X359 OUTN a_7845_16440# cap_mim_2f0_m4m5_noshield c_width=5u c_length=5u
X360 OUTP a_1825_16440# cap_mim_2f0_m4m5_noshield c_width=5u c_length=5u
X361 VSS a_7460_33166# a_7845_16440# VSS nfet_03v3 ad=1.325p pd=5.53u as=1.325p ps=5.53u w=5u l=0.28u
X362 a_7845_16440# a_7460_33166# VSS VSS nfet_03v3 ad=1.325p pd=5.53u as=1.325p ps=5.53u w=5u l=0.28u
X363 a_7460_33166# RFIN cap_mim_2f0_m4m5_noshield c_width=5u c_length=5u
X364 OUTN a_7845_16440# cap_mim_2f0_m4m5_noshield c_width=5u c_length=5u
X365 VDD a_1825_16440# VSS ppolyf_u_1k r_width=10u r_length=2u
X366 OUTN a_7845_16440# cap_mim_2f0_m4m5_noshield c_width=5u c_length=5u
X367 a_7845_16440# a_7460_33166# VSS VSS nfet_03v3 ad=1.325p pd=5.53u as=1.325p ps=5.53u w=5u l=0.28u
X368 a_7460_33166# RFIN cap_mim_2f0_m4m5_noshield c_width=5u c_length=5u
X369 VSS a_7460_33166# a_7845_16440# VSS nfet_03v3 ad=1.325p pd=5.53u as=1.325p ps=5.53u w=5u l=0.28u
X370 a_7460_33166# RFIN cap_mim_2f0_m4m5_noshield c_width=5u c_length=5u
X371 a_7460_33166# RFIN cap_mim_2f0_m4m5_noshield c_width=5u c_length=5u
X372 OUTN a_7845_16440# cap_mim_2f0_m4m5_noshield c_width=5u c_length=5u
X373 VSS a_7460_33166# a_7845_16440# VSS nfet_03v3 ad=1.325p pd=5.53u as=1.325p ps=5.53u w=5u l=0.28u
X374 a_7460_33166# RFIN cap_mim_2f0_m4m5_noshield c_width=5u c_length=5u
X375 OUTP a_1825_16440# cap_mim_2f0_m4m5_noshield c_width=5u c_length=5u
X376 a_7845_16440# a_7460_33166# VSS VSS nfet_03v3 ad=1.325p pd=5.53u as=1.325p ps=5.53u w=5u l=0.28u
X377 OUTN a_7845_16440# cap_mim_2f0_m4m5_noshield c_width=5u c_length=5u
X378 a_7845_16440# a_7460_33166# VSS VSS nfet_03v3 ad=1.325p pd=5.53u as=2.225p ps=10.89u w=5u l=0.28u
X379 OUTN a_7845_16440# cap_mim_2f0_m4m5_noshield c_width=5u c_length=5u
X380 a_7845_16440# a_7460_33166# VSS VSS nfet_03v3 ad=1.325p pd=5.53u as=1.325p ps=5.53u w=5u l=0.28u
X381 a_7845_16440# a_7460_33166# VSS VSS nfet_03v3 ad=1.325p pd=5.53u as=2.225p ps=10.89u w=5u l=0.28u
X382 a_7460_33166# RFIN cap_mim_2f0_m4m5_noshield c_width=5u c_length=5u
X383 a_7460_33166# RFIN cap_mim_2f0_m4m5_noshield c_width=5u c_length=5u
X384 OUTP a_1825_16440# cap_mim_2f0_m4m5_noshield c_width=5u c_length=5u
X385 a_7845_16440# a_7460_33166# VSS VSS nfet_03v3 ad=1.325p pd=5.53u as=1.325p ps=5.53u w=5u l=0.28u
C0 PB a_7880_31766# 0.10029f
C1 VDD a_1825_16440# 4.32888f
C2 VDD a_5700_16380# 0.01888f
C3 PB a_7845_16440# 2.57381f
C4 VDD a_7460_33166# 2.22435f
C5 OUTN a_7845_16440# 29.7338f
C6 a_17180_32731# VDD 3.30247f
C7 a_16696_16380# VDD 0.02209f
C8 a_8280_31044# a_7460_33166# 0.05144f
C9 a_7845_16440# a_13016_17751# 0.02197f
C10 a_16124_16380# a_7880_31766# 0.06298f
C11 VDD a_28904_30800# 3.33985f
C12 PB a_1825_16440# 0.89035f
C13 OUTN OUTP 1.18904f
C14 VDD a_7584_17751# 0.01798f
C15 a_7845_16440# a_7880_31766# 0.15236f
C16 a_17180_32731# a_17180_30800# 0.01104f
C17 PB a_7460_33166# 0.16365f
C18 PB a_17180_32731# 0.0436f
C19 a_17180_30800# VDD 3.33985f
C20 PB VDD 55.336f
C21 OUTN VDD 0.94938f
C22 a_7584_16380# VDD 0.01888f
C23 VDD a_28904_32731# 3.30247f
C24 RFIN a_1564_16380# 0.06905f
C25 RFIN a_1825_16440# 8.87973f
C26 a_7880_31766# a_1825_16440# 0.20256f
C27 RFIN a_5700_16380# 0.05282f
C28 VDD a_13016_17751# 0.01798f
C29 a_7845_16440# OUTP 4.93824f
C30 RFIN a_7460_33166# 29.7616f
C31 a_7460_33166# a_7880_31766# 0.23229f
C32 a_7845_16440# a_1825_16440# 2.34542f
C33 a_28904_30800# a_28904_32731# 0.01104f
C34 PB a_17180_30800# 0.0436f
C35 a_16696_16380# a_7880_31766# 0.06804f
C36 VDD a_16124_16380# 0.02209f
C37 a_7845_16440# a_7460_33166# 7.86899f
C38 RFIN VDD 2.25449f
C39 VDD a_7880_31766# 5.26492f
C40 VDD a_19076_16380# 0.01567f
C41 VDD a_7845_16440# 12.2799f
C42 a_8280_31044# a_7880_31766# 0.08407f
C43 a_1825_16440# OUTP 29.7338f
C44 a_18504_16380# VDD 0.01567f
C45 a_5700_16380# a_1825_16440# 0.01991f
C46 a_7460_33166# a_1825_16440# 0.28391f
C47 VDD a_13016_16380# 0.01888f
C48 PB RFIN 0.26665f
C49 VDD a_1564_16380# 0.01888f
C50 VDD OUTP 2.93327f
R0 PB PB.n42 45.1445
R1 PB.n21 PB.t0 36.0256
R2 PB.n31 PB.t21 36.0256
R3 PB.n0 PB.t22 34.3534
R4 PB.n10 PB.t43 34.3534
R5 PB.n30 PB.n29 21.4256
R6 PB.n29 PB.n28 21.4256
R7 PB.n28 PB.n27 21.4256
R8 PB.n27 PB.n26 21.4256
R9 PB.n26 PB.n25 21.4256
R10 PB.n25 PB.n24 21.4256
R11 PB.n24 PB.n23 21.4256
R12 PB.n23 PB.n22 21.4256
R13 PB.n22 PB.n21 21.4256
R14 PB.n40 PB.n39 21.4256
R15 PB.n39 PB.n38 21.4256
R16 PB.n38 PB.n37 21.4256
R17 PB.n37 PB.n36 21.4256
R18 PB.n36 PB.n35 21.4256
R19 PB.n35 PB.n34 21.4256
R20 PB.n34 PB.n33 21.4256
R21 PB.n33 PB.n32 21.4256
R22 PB.n32 PB.n31 21.4256
R23 PB.n9 PB.n8 19.7534
R24 PB.n8 PB.n7 19.7534
R25 PB.n7 PB.n6 19.7534
R26 PB.n6 PB.n5 19.7534
R27 PB.n5 PB.n4 19.7534
R28 PB.n4 PB.n3 19.7534
R29 PB.n3 PB.n2 19.7534
R30 PB.n2 PB.n1 19.7534
R31 PB.n1 PB.n0 19.7534
R32 PB.n19 PB.n18 19.7534
R33 PB.n18 PB.n17 19.7534
R34 PB.n17 PB.n16 19.7534
R35 PB.n16 PB.n15 19.7534
R36 PB.n15 PB.n14 19.7534
R37 PB.n14 PB.n13 19.7534
R38 PB.n13 PB.n12 19.7534
R39 PB.n12 PB.n11 19.7534
R40 PB.n11 PB.n10 19.7534
R41 PB.n9 PB.t32 14.6005
R42 PB.n8 PB.t31 14.6005
R43 PB.n7 PB.t30 14.6005
R44 PB.n6 PB.t29 14.6005
R45 PB.n5 PB.t28 14.6005
R46 PB.n4 PB.t27 14.6005
R47 PB.n3 PB.t26 14.6005
R48 PB.n2 PB.t25 14.6005
R49 PB.n1 PB.t24 14.6005
R50 PB.n0 PB.t23 14.6005
R51 PB.n19 PB.t33 14.6005
R52 PB.n18 PB.t34 14.6005
R53 PB.n17 PB.t35 14.6005
R54 PB.n16 PB.t36 14.6005
R55 PB.n15 PB.t37 14.6005
R56 PB.n14 PB.t38 14.6005
R57 PB.n13 PB.t39 14.6005
R58 PB.n12 PB.t40 14.6005
R59 PB.n11 PB.t41 14.6005
R60 PB.n10 PB.t42 14.6005
R61 PB.n30 PB.t10 14.6005
R62 PB.n29 PB.t9 14.6005
R63 PB.n28 PB.t8 14.6005
R64 PB.n27 PB.t7 14.6005
R65 PB.n26 PB.t6 14.6005
R66 PB.n25 PB.t5 14.6005
R67 PB.n24 PB.t4 14.6005
R68 PB.n23 PB.t3 14.6005
R69 PB.n22 PB.t2 14.6005
R70 PB.n21 PB.t1 14.6005
R71 PB.n40 PB.t11 14.6005
R72 PB.n39 PB.t12 14.6005
R73 PB.n38 PB.t13 14.6005
R74 PB.n37 PB.t14 14.6005
R75 PB.n36 PB.t15 14.6005
R76 PB.n35 PB.t16 14.6005
R77 PB.n34 PB.t17 14.6005
R78 PB.n33 PB.t18 14.6005
R79 PB.n32 PB.t19 14.6005
R80 PB.n31 PB.t20 14.6005
R81 PB.n42 PB.n20 13.9955
R82 PB.n42 PB.n41 11.0795
R83 PB.n41 PB.n30 10.7131
R84 PB.n41 PB.n40 10.7131
R85 PB.n20 PB.n9 9.87697
R86 PB.n20 PB.n19 9.87697
R87 a_1749_17589.n0 a_1749_17589.t9 96.1964
R88 a_1749_17589.n11 a_1749_17589.t32 96.1964
R89 a_1749_17589.n0 a_1749_17589.t10 84.6023
R90 a_1749_17589.n1 a_1749_17589.t11 84.6023
R91 a_1749_17589.n2 a_1749_17589.t12 84.6023
R92 a_1749_17589.n3 a_1749_17589.t13 84.6023
R93 a_1749_17589.n4 a_1749_17589.t14 84.6023
R94 a_1749_17589.n5 a_1749_17589.t15 84.6023
R95 a_1749_17589.n6 a_1749_17589.t16 84.6023
R96 a_1749_17589.n7 a_1749_17589.t17 84.6023
R97 a_1749_17589.n8 a_1749_17589.t18 84.6023
R98 a_1749_17589.n9 a_1749_17589.t19 84.6023
R99 a_1749_17589.n10 a_1749_17589.t20 84.6023
R100 a_1749_17589.n21 a_1749_17589.t21 84.6023
R101 a_1749_17589.n20 a_1749_17589.t22 84.6023
R102 a_1749_17589.n19 a_1749_17589.t23 84.6023
R103 a_1749_17589.n18 a_1749_17589.t24 84.6023
R104 a_1749_17589.n17 a_1749_17589.t25 84.6023
R105 a_1749_17589.n16 a_1749_17589.t26 84.6023
R106 a_1749_17589.n15 a_1749_17589.t27 84.6023
R107 a_1749_17589.n14 a_1749_17589.t28 84.6023
R108 a_1749_17589.n13 a_1749_17589.t29 84.6023
R109 a_1749_17589.n12 a_1749_17589.t30 84.6023
R110 a_1749_17589.n11 a_1749_17589.t31 84.6023
R111 a_1749_17589.t6 a_1749_17589.t8 14.0486
R112 a_1749_17589.t6 a_1749_17589.n22 13.7496
R113 a_1749_17589.n12 a_1749_17589.n11 11.5946
R114 a_1749_17589.n13 a_1749_17589.n12 11.5946
R115 a_1749_17589.n14 a_1749_17589.n13 11.5946
R116 a_1749_17589.n15 a_1749_17589.n14 11.5946
R117 a_1749_17589.n16 a_1749_17589.n15 11.5946
R118 a_1749_17589.n17 a_1749_17589.n16 11.5946
R119 a_1749_17589.n18 a_1749_17589.n17 11.5946
R120 a_1749_17589.n19 a_1749_17589.n18 11.5946
R121 a_1749_17589.n20 a_1749_17589.n19 11.5946
R122 a_1749_17589.n21 a_1749_17589.n20 11.5946
R123 a_1749_17589.n10 a_1749_17589.n9 11.5946
R124 a_1749_17589.n9 a_1749_17589.n8 11.5946
R125 a_1749_17589.n8 a_1749_17589.n7 11.5946
R126 a_1749_17589.n7 a_1749_17589.n6 11.5946
R127 a_1749_17589.n6 a_1749_17589.n5 11.5946
R128 a_1749_17589.n5 a_1749_17589.n4 11.5946
R129 a_1749_17589.n4 a_1749_17589.n3 11.5946
R130 a_1749_17589.n3 a_1749_17589.n2 11.5946
R131 a_1749_17589.n2 a_1749_17589.n1 11.5946
R132 a_1749_17589.n1 a_1749_17589.n0 11.5946
R133 a_1749_17589.n22 a_1749_17589.n21 5.79756
R134 a_1749_17589.n22 a_1749_17589.n10 5.79756
R135 a_1749_17589.t0 a_1749_17589.t5 5.32791
R136 a_1749_17589.t5 a_1749_17589.t6 5.25779
R137 a_1749_17589.t1 a_1749_17589.t0 4.5005
R138 a_1749_17589.t4 a_1749_17589.t3 3.39328
R139 a_1749_17589.t3 a_1749_17589.t2 1.62693
R140 a_1749_17589.t2 a_1749_17589.t1 1.45095
R141 a_7460_31044.t5 a_7460_31044.t7 14.5959
R142 a_7460_31044.t1 a_7460_31044.t0 10.2164
R143 a_7460_31044.t0 a_7460_31044.t4 6.5732
R144 a_7460_31044.t3 a_7460_31044.t2 3.79179
R145 a_7460_31044.t2 a_7460_31044.t1 2.38952
R146 a_7460_31044.t4 a_7460_31044.t5 1.2794
C51 OUTN VSS 30.0696f
C52 OUTP VSS 40.962f
C53 PB VSS 17.82074f
C54 RFIN VSS 37.5276f
C55 VDD VSS 0.35064p
C56 a_19076_16380# VSS 0.72809f
C57 a_18504_16380# VSS 0.73108f
C58 a_16696_16380# VSS 0.9592f
C59 a_16124_16380# VSS 0.95739f
C60 a_13016_16380# VSS 0.8895f
C61 a_7584_16380# VSS 0.89324f
C62 a_13016_17751# VSS 0.86856f
C63 a_7584_17751# VSS 0.88394f
C64 a_5700_16380# VSS 0.81731f
C65 a_1564_16380# VSS 0.81731f
C66 a_28904_30800# VSS 0.21076f
C67 a_17180_30800# VSS 0.21076f
C68 a_28904_32731# VSS 0.19737f
C69 a_17180_32731# VSS 0.19737f
C70 a_7845_16440# VSS 94.7461f ; **FLOATING
C71 a_8280_31044# VSS 2.68345f
C72 a_7880_31766# VSS 6.39814f ; **FLOATING
C73 a_7460_33166# VSS 68.34f ; **FLOATING
C74 a_7060_31044# VSS 2.63799f ; **FLOATING
C75 a_1825_16440# VSS 38.3245f ; **FLOATING
C76 a_7460_31044.t1 VSS 0.25461f ; **FLOATING
C77 a_7460_31044.t0 VSS 1.26081f ; **FLOATING
C78 a_7460_31044.t3 VSS 0.04742f ; **FLOATING
C79 a_7460_31044.t2 VSS 0.20474f ; **FLOATING
C80 a_7460_31044.t7 VSS 29.0183f ; **FLOATING
C81 a_7460_31044.t5 VSS 0.30224f ; **FLOATING
C82 a_7460_31044.t4 VSS 0.26923f ; **FLOATING
C83 a_1749_17589.t6 VSS 1.75467f ; **FLOATING
C84 a_1749_17589.t4 VSS 0.07122f ; **FLOATING
C85 a_1749_17589.t2 VSS 0.32007f ; **FLOATING
C86 a_1749_17589.t3 VSS 0.29597f ; **FLOATING
C87 a_1749_17589.t1 VSS 0.21481f ; **FLOATING
C88 a_1749_17589.t20 VSS 0.01181f ; **FLOATING
C89 a_1749_17589.t19 VSS 0.01181f ; **FLOATING
C90 a_1749_17589.t18 VSS 0.01181f ; **FLOATING
C91 a_1749_17589.t17 VSS 0.01181f ; **FLOATING
C92 a_1749_17589.t16 VSS 0.01181f ; **FLOATING
C93 a_1749_17589.t15 VSS 0.01181f ; **FLOATING
C94 a_1749_17589.t14 VSS 0.01181f ; **FLOATING
C95 a_1749_17589.t13 VSS 0.01181f ; **FLOATING
C96 a_1749_17589.t12 VSS 0.01181f ; **FLOATING
C97 a_1749_17589.t11 VSS 0.01181f ; **FLOATING
C98 a_1749_17589.t10 VSS 0.01181f ; **FLOATING
C99 a_1749_17589.t9 VSS 0.01271f ; **FLOATING
C100 a_1749_17589.n0 VSS 0.01485f ; **FLOATING
C101 a_1749_17589.t21 VSS 0.01181f ; **FLOATING
C102 a_1749_17589.t22 VSS 0.01181f ; **FLOATING
C103 a_1749_17589.t23 VSS 0.01181f ; **FLOATING
C104 a_1749_17589.t24 VSS 0.01181f ; **FLOATING
C105 a_1749_17589.t25 VSS 0.01181f ; **FLOATING
C106 a_1749_17589.t26 VSS 0.01181f ; **FLOATING
C107 a_1749_17589.t27 VSS 0.01181f ; **FLOATING
C108 a_1749_17589.t28 VSS 0.01181f ; **FLOATING
C109 a_1749_17589.t29 VSS 0.01181f ; **FLOATING
C110 a_1749_17589.t30 VSS 0.01181f ; **FLOATING
C111 a_1749_17589.t31 VSS 0.01181f ; **FLOATING
C112 a_1749_17589.t32 VSS 0.01271f ; **FLOATING
C113 a_1749_17589.n11 VSS 0.01485f ; **FLOATING
C114 a_1749_17589.n22 VSS 0.30439f ; **FLOATING
C115 a_1749_17589.t8 VSS 42.2021f ; **FLOATING
C116 a_1749_17589.t5 VSS 0.851f ; **FLOATING
C117 a_1749_17589.t0 VSS 1.72942f ; **FLOATING
C118 PB.t32 VSS 0.99326f ; **FLOATING
C119 PB.t31 VSS 0.99326f ; **FLOATING
C120 PB.t30 VSS 0.99326f ; **FLOATING
C121 PB.t29 VSS 0.99326f ; **FLOATING
C122 PB.t28 VSS 0.99326f ; **FLOATING
C123 PB.t27 VSS 0.99326f ; **FLOATING
C124 PB.t26 VSS 0.99326f ; **FLOATING
C125 PB.t25 VSS 0.99326f ; **FLOATING
C126 PB.t24 VSS 0.99326f ; **FLOATING
C127 PB.t23 VSS 0.99326f ; **FLOATING
C128 PB.t22 VSS 1.29179f ; **FLOATING
C129 PB.n0 VSS 0.74648f ; **FLOATING
C130 PB.n1 VSS 0.52582f ; **FLOATING
C131 PB.n2 VSS 0.52582f ; **FLOATING
C132 PB.n3 VSS 0.52582f ; **FLOATING
C133 PB.n4 VSS 0.52582f ; **FLOATING
C134 PB.n5 VSS 0.52582f ; **FLOATING
C135 PB.n6 VSS 0.52582f ; **FLOATING
C136 PB.n7 VSS 0.52582f ; **FLOATING
C137 PB.n8 VSS 0.52582f ; **FLOATING
C138 PB.n9 VSS 0.48808f ; **FLOATING
C139 PB.t33 VSS 0.99326f ; **FLOATING
C140 PB.t34 VSS 0.99326f ; **FLOATING
C141 PB.t35 VSS 0.99326f ; **FLOATING
C142 PB.t36 VSS 0.99326f ; **FLOATING
C143 PB.t37 VSS 0.99326f ; **FLOATING
C144 PB.t38 VSS 0.99326f ; **FLOATING
C145 PB.t39 VSS 0.99326f ; **FLOATING
C146 PB.t40 VSS 0.99326f ; **FLOATING
C147 PB.t41 VSS 0.99326f ; **FLOATING
C148 PB.t42 VSS 0.99326f ; **FLOATING
C149 PB.t43 VSS 1.29179f ; **FLOATING
C150 PB.n10 VSS 0.74648f ; **FLOATING
C151 PB.n11 VSS 0.52582f ; **FLOATING
C152 PB.n12 VSS 0.52582f ; **FLOATING
C153 PB.n13 VSS 0.52582f ; **FLOATING
C154 PB.n14 VSS 0.52582f ; **FLOATING
C155 PB.n15 VSS 0.52582f ; **FLOATING
C156 PB.n16 VSS 0.52582f ; **FLOATING
C157 PB.n17 VSS 0.52582f ; **FLOATING
C158 PB.n18 VSS 0.52582f ; **FLOATING
C159 PB.n19 VSS 0.48808f ; **FLOATING
C160 PB.n20 VSS 3.19719f ; **FLOATING
C161 PB.t10 VSS 0.99326f ; **FLOATING
C162 PB.t9 VSS 0.99326f ; **FLOATING
C163 PB.t8 VSS 0.99326f ; **FLOATING
C164 PB.t7 VSS 0.99326f ; **FLOATING
C165 PB.t6 VSS 0.99326f ; **FLOATING
C166 PB.t5 VSS 0.99326f ; **FLOATING
C167 PB.t4 VSS 0.99326f ; **FLOATING
C168 PB.t3 VSS 0.99326f ; **FLOATING
C169 PB.t2 VSS 0.99326f ; **FLOATING
C170 PB.t1 VSS 0.99326f ; **FLOATING
C171 PB.t0 VSS 1.28844f ; **FLOATING
C172 PB.n21 VSS 0.70411f ; **FLOATING
C173 PB.n22 VSS 0.50296f ; **FLOATING
C174 PB.n23 VSS 0.50296f ; **FLOATING
C175 PB.n24 VSS 0.50296f ; **FLOATING
C176 PB.n25 VSS 0.50296f ; **FLOATING
C177 PB.n26 VSS 0.50296f ; **FLOATING
C178 PB.n27 VSS 0.50296f ; **FLOATING
C179 PB.n28 VSS 0.50296f ; **FLOATING
C180 PB.n29 VSS 0.50296f ; **FLOATING
C181 PB.n30 VSS 0.46733f ; **FLOATING
C182 PB.t11 VSS 0.99326f ; **FLOATING
C183 PB.t12 VSS 0.99326f ; **FLOATING
C184 PB.t13 VSS 0.99326f ; **FLOATING
C185 PB.t14 VSS 0.99326f ; **FLOATING
C186 PB.t15 VSS 0.99326f ; **FLOATING
C187 PB.t16 VSS 0.99326f ; **FLOATING
C188 PB.t17 VSS 0.99326f ; **FLOATING
C189 PB.t18 VSS 0.99326f ; **FLOATING
C190 PB.t19 VSS 0.99326f ; **FLOATING
C191 PB.t20 VSS 0.99326f ; **FLOATING
C192 PB.t21 VSS 1.28844f ; **FLOATING
C193 PB.n31 VSS 0.70411f ; **FLOATING
C194 PB.n32 VSS 0.50296f ; **FLOATING
C195 PB.n33 VSS 0.50296f ; **FLOATING
C196 PB.n34 VSS 0.50296f ; **FLOATING
C197 PB.n35 VSS 0.50296f ; **FLOATING
C198 PB.n36 VSS 0.50296f ; **FLOATING
C199 PB.n37 VSS 0.50296f ; **FLOATING
C200 PB.n38 VSS 0.50296f ; **FLOATING
C201 PB.n39 VSS 0.50296f ; **FLOATING
C202 PB.n40 VSS 0.46733f ; **FLOATING
C203 PB.n41 VSS 3.11099f ; **FLOATING
C204 PB.n42 VSS 2.25145f ; **FLOATING
.ends
