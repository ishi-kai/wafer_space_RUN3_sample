* NGSPICE file created from bias_gen_flat.ext - technology: gf180mcuD

.subckt bias_gen_flat VSS VDD NB PB
X0 NB VSS cap_mim_2f0_m4m5_noshield c_width=20u c_length=20u
X1 a_2169_11400# a_1749_13109# VDD VDD pfet_03v3 ad=3.56p pd=16.89u as=3.56p ps=16.89u w=8u l=2u
X2 VSS NB NB VSS nfet_03v3 ad=3.56p pd=16.89u as=2.12p ps=8.53u w=8u l=2u
X3 VDD PB PB VDD pfet_03v3 ad=2.12p pd=8.53u as=2.12p ps=8.53u w=8u l=2u
X4 a_1749_13109# a_2169_11400# a_11760_16860# VSS nfet_03v3 ad=2.12p pd=8.53u as=3.56p ps=16.89u w=8u l=2u
X5 a_1749_13109# a_1749_13109# VDD VDD pfet_03v3 ad=3.56p pd=16.89u as=3.56p ps=16.89u w=8u l=2u
X6 VDD PB PB VDD pfet_03v3 ad=3.56p pd=16.89u as=2.12p ps=8.53u w=8u l=2u
X7 PB PB VDD VDD pfet_03v3 ad=2.12p pd=8.53u as=3.56p ps=16.89u w=8u l=2u
X8 NB a_1749_13109# VDD VDD pfet_03v3 ad=3.56p pd=16.89u as=3.56p ps=16.89u w=8u l=2u
X9 a_1749_13109# a_9409_1802# VSS VSS nfet_03v3 ad=0.445p pd=2.89u as=0.445p ps=2.89u w=1u l=1u
X10 a_9409_1802# a_2169_11400# VSS VSS nfet_03v3 ad=0.89p pd=4.89u as=0.89p ps=4.89u w=2u l=1u
X11 a_11760_16860# VSS VSS ppolyf_u_1k r_width=1u r_length=4.6u
X12 a_2169_11400# a_2169_11400# VSS VSS nfet_03v3 ad=1.78p pd=8.89u as=1.78p ps=8.89u w=4u l=2u
X13 a_11760_16860# a_2169_11400# a_1749_13109# VSS nfet_03v3 ad=3.56p pd=16.89u as=2.12p ps=8.53u w=8u l=2u
X14 NB NB VSS VSS nfet_03v3 ad=2.12p pd=8.53u as=3.56p ps=16.89u w=8u l=2u
X15 PB a_2169_11400# VSS VSS nfet_03v3 ad=1.78p pd=8.89u as=1.78p ps=8.89u w=4u l=2u
X16 PB PB VDD VDD pfet_03v3 ad=2.12p pd=8.53u as=2.12p ps=8.53u w=8u l=2u
X17 VDD PB cap_mim_2f0_m4m5_noshield c_width=20u c_length=20u
X18 a_9409_1802# VSS VDD VDD pfet_03v3 ad=0.445p pd=2.89u as=0.445p ps=2.89u w=1u l=20u
C0 a_1749_13109# a_2318_11340# 0.01545f
C1 a_1749_13109# a_11760_16860# 0.24552f
C2 a_2169_11400# a_5420_5880# 0.01727f
C3 a_1749_13109# a_5118_11340# 0.26291f
C4 a_11300_16800# a_2169_11400# 0.04915f
C5 a_2169_11400# a_11224_11340# 0.02277f
C6 a_9318_5880# PB 0.11836f
C7 a_1749_13109# NB 1.68581f
C8 a_9409_1802# a_1749_13109# 0.18095f
C9 a_1260_1742# VDD 5.8165f
C10 a_9409_1802# a_13040_5880# 0.01563f
C11 a_1749_13109# a_7918_11340# 0.01545f
C12 a_1749_13109# a_11638_6222# 0.02553f
C13 a_1749_13109# a_4020_11340# 0.01545f
C14 a_6820_11340# a_1749_13109# 0.01545f
C15 a_9558_1742# a_9409_1802# 0.13089f
C16 VDD a_2318_11340# 3.14556f
C17 VDD a_11760_16860# 0.33039f
C18 a_11760_16860# PB 0.04359f
C19 a_1749_13109# VDD 5.15283f
C20 a_1749_13109# PB 0.08134f
C21 VDD a_1220_5880# 3.38049f
C22 a_7918_11340# NB 0.29507f
C23 a_8220_5880# PB 0.02393f
C24 a_9409_1802# a_11638_6222# 0.01003f
C25 a_2169_11400# a_9318_5880# 0.01673f
C26 VDD a_5118_11340# 3.15665f
C27 a_9558_1742# VDD 5.74424f
C28 a_2169_11400# a_2318_11340# 0.28326f
C29 a_2169_11400# a_11760_16860# 0.79876f
C30 VDD NB 1.737f
C31 NB PB 0.2344f
C32 a_9409_1802# VDD 0.93148f
C33 VDD a_3836_5880# 3.38049f
C34 PB a_3836_5880# 0.02715f
C35 VDD a_7918_11340# 3.13838f
C36 a_2169_11400# a_1749_13109# 1.87842f
C37 a_11300_16800# a_11760_16860# 0.21789f
C38 a_1749_13109# a_9620_11340# 0.06302f
C39 VDD a_4020_11340# 3.35763f
C40 a_6820_11340# VDD 3.35763f
C41 a_2169_11400# a_8220_5880# 0.01558f
C42 a_2169_11400# a_13040_5880# 0.01266f
C43 a_10940_6222# a_1749_13109# 0.01318f
C44 a_11224_11340# a_1749_13109# 0.01066f
C45 a_6518_5880# PB 0.02144f
C46 VDD PB 10.1971f
C47 a_11760_16860# a_12904_16800# 0.24005f
C48 a_2169_11400# NB 0.38844f
C49 NB a_9620_11340# 0.06245f
C50 a_9409_1802# a_2169_11400# 0.12504f
C51 a_2169_11400# a_3836_5880# 0.02279f
C52 VDD a_1220_11340# 3.35763f
C53 a_10940_6222# a_9409_1802# 0.01905f
C54 a_13738_5880# a_9409_1802# 0.04433f
C55 a_5420_5880# PB 0.03229f
C56 a_2169_11400# a_6518_5880# 0.13613f
C57 a_2169_11400# VDD 2.22363f
C58 a_2169_11400# PB 1.35271f
C59 PB VSS 15.8977f
C60 NB VSS 24.5526f
C61 VDD VSS 0.20423p
C62 a_9558_1742# VSS 0.32211f
C63 a_1260_1742# VSS 0.32211f
C64 a_13738_5880# VSS 0.7641f
C65 a_13040_5880# VSS 0.80204f
C66 a_11638_6222# VSS 0.48088f
C67 a_10940_6222# VSS 0.49495f
C68 a_9409_1802# VSS 4.16077f ; **FLOATING
C69 a_9318_5880# VSS 1.99573f
C70 a_8220_5880# VSS 2.10209f
C71 a_6518_5880# VSS 1.99573f
C72 a_5420_5880# VSS 2.09774f
C73 a_3836_5880# VSS 0.22758f
C74 a_1220_5880# VSS 0.22758f
C75 a_11224_11340# VSS 3.66301f
C76 a_9620_11340# VSS 3.64474f
C77 a_7918_11340# VSS 0.31681f
C78 a_6820_11340# VSS 0.30475f
C79 a_5118_11340# VSS 0.30475f
C80 a_4020_11340# VSS 0.30475f
C81 a_2318_11340# VSS 0.30475f
C82 a_1220_11340# VSS 0.30475f
C83 a_12904_16800# VSS 3.30009f
C84 a_1749_13109# VSS 8.1361f ; **FLOATING
C85 a_11760_16860# VSS 3.31649f ; **FLOATING
C86 a_11300_16800# VSS 3.30009f
C87 a_2169_11400# VSS 13.8864f ; **FLOATING
.ends
