* NGSPICE file created from afc_dac_flat.ext - technology: gf180mcuD

.subckt afc_dac_flat VSS VDD D0 D1 D2 D3 D4 D5 D6 D7 OUT
X0 VDD a_1793_5969# a_1869_6179# VDD pfet_03v3 ad=1.59p pd=6.53u as=1.59p ps=6.53u w=6u l=0.28u
X1 a_6100_17184# a_6833_5969# VDD VDD pfet_03v3 ad=1.59p pd=6.53u as=1.59p ps=6.53u w=6u l=0.28u
X2 a_2600_25606# a_4000_23484# VSS ppolyf_u_1k r_width=2u r_length=10u
X3 VDD a_1793_5969# a_1869_6179# VDD pfet_03v3 ad=1.59p pd=6.53u as=1.59p ps=6.53u w=6u l=0.28u
X4 a_4345_6179# a_4269_7089# VDD VDD pfet_03v3 ad=1.59p pd=6.53u as=1.59p ps=6.53u w=6u l=0.28u
X5 a_10300_18646# a_11700_17184# VSS ppolyf_u_1k r_width=2u r_length=6.7u
X6 VDD a_4593_5969# a_4669_6179# VDD pfet_03v3 ad=1.59p pd=6.53u as=1.59p ps=6.53u w=6u l=0.28u
X7 a_11000_25606# a_9600_23484# VSS ppolyf_u_1k r_width=2u r_length=10u
X8 a_6100_17184# a_6833_5969# VDD VDD pfet_03v3 ad=1.59p pd=6.53u as=1.59p ps=6.53u w=6u l=0.28u
X9 VDD a_4593_5969# a_4669_6179# VDD pfet_03v3 ad=1.59p pd=6.53u as=1.59p ps=6.53u w=6u l=0.28u
X10 a_4345_6179# a_4269_7089# VSS VSS nfet_03v3 ad=1.06p pd=4.53u as=1.78p ps=8.89u w=4u l=0.28u
X11 a_7500_19306# OUT VSS ppolyf_u_1k r_width=2u r_length=10u
X12 a_7500_25606# a_8900_23484# VSS ppolyf_u_1k r_width=2u r_length=10u
X13 a_1545_6179# a_1469_7509# VSS VSS nfet_03v3 ad=1.06p pd=4.53u as=1.78p ps=8.89u w=4u l=0.28u
X14 a_2600_19306# a_2600_11444# VSS ppolyf_u_1k r_width=2u r_length=10u
X15 a_1900_12906# a_3300_11444# VSS ppolyf_u_1k r_width=2u r_length=6.7u
X16 a_14500_18646# a_13100_23484# VSS ppolyf_u_1k r_width=2u r_length=6.7u
X17 a_6585_6179# a_6509_7089# VDD VDD pfet_03v3 ad=1.59p pd=6.53u as=1.59p ps=6.53u w=6u l=0.28u
X18 a_15900_25606# a_14500_23484# VSS ppolyf_u_1k r_width=2u r_length=10u
X19 VDD a_6833_5969# a_6100_17184# VDD pfet_03v3 ad=1.59p pd=6.53u as=1.59p ps=6.53u w=6u l=0.28u
X20 a_4905_1460# D0 VSS VSS nfet_03v3 ad=0.445p pd=2.89u as=0.445p ps=2.89u w=1u l=0.28u
X21 a_10409_11499# a_6585_1460# VSS VSS nfet_03v3 ad=1.06p pd=4.53u as=1.06p ps=4.53u w=4u l=0.28u
X22 a_4345_6179# a_4269_7089# VDD VDD pfet_03v3 ad=1.59p pd=6.53u as=2.67p ps=12.89u w=6u l=0.28u
X23 VDD a_6833_5969# a_6100_17184# VDD pfet_03v3 ad=1.59p pd=6.53u as=1.59p ps=6.53u w=6u l=0.28u
X24 VSS a_4593_5969# a_4669_6179# VSS nfet_03v3 ad=1.78p pd=8.89u as=1.06p ps=4.53u w=4u l=0.28u
X25 a_6585_1460# D1 VSS VSS nfet_03v3 ad=0.445p pd=2.89u as=0.445p ps=2.89u w=1u l=0.28u
X26 a_5400_19306# a_4000_17184# VSS ppolyf_u_1k r_width=2u r_length=10u
X27 a_5400_25606# a_6800_23484# VSS ppolyf_u_1k r_width=2u r_length=10u
X28 a_6100_12906# OUT VSS ppolyf_u_1k r_width=2u r_length=6.7u
X29 a_8200_23484# a_15900_17184# VSS ppolyf_u_1k r_width=2u r_length=6.7u
X30 a_1900_25606# VSS VSS ppolyf_u_1k r_width=2u r_length=10u
X31 a_11000_18646# a_12400_17184# VSS ppolyf_u_1k r_width=2u r_length=6.7u
X32 a_13800_25606# a_4700_12906# VSS ppolyf_u_1k r_width=2u r_length=10u
X33 a_6585_6179# a_6509_7089# VDD VDD pfet_03v3 ad=1.59p pd=6.53u as=2.67p ps=12.89u w=6u l=0.28u
X34 a_6509_7089# D4 VSS VSS nfet_03v3 ad=0.445p pd=2.89u as=0.445p ps=2.89u w=1u l=0.28u
X35 a_7500_19306# a_8200_17184# VSS ppolyf_u_1k r_width=2u r_length=10u
X36 a_8200_25606# a_9600_23484# VSS ppolyf_u_1k r_width=2u r_length=10u
X37 VSS a_6585_1460# a_10409_11499# VSS nfet_03v3 ad=1.78p pd=8.89u as=1.06p ps=4.53u w=4u l=0.28u
X38 a_4905_1460# D0 VDD VDD pfet_03v3 ad=0.89p pd=4.89u as=0.89p ps=4.89u w=2u l=0.28u
X39 a_4269_7089# D2 VSS VSS nfet_03v3 ad=0.445p pd=2.89u as=0.445p ps=2.89u w=1u l=0.28u
X40 a_1869_6179# a_1793_5969# VSS VSS nfet_03v3 ad=1.06p pd=4.53u as=1.06p ps=4.53u w=4u l=0.28u
X41 a_6800_23484# a_4905_1460# VSS VSS nfet_03v3 ad=1.06p pd=4.53u as=1.78p ps=8.89u w=4u l=0.28u
X42 a_1900_19306# a_3300_17184# VSS ppolyf_u_1k r_width=2u r_length=10u
X43 a_4700_25606# a_3300_23484# VSS ppolyf_u_1k r_width=2u r_length=10u
X44 VDD a_1469_7509# a_1545_6179# VDD pfet_03v3 ad=1.59p pd=6.53u as=1.59p ps=6.53u w=6u l=0.28u
X45 a_2600_12906# a_4000_11444# VSS ppolyf_u_1k r_width=2u r_length=6.7u
X46 a_15200_18646# a_4700_12906# VSS ppolyf_u_1k r_width=2u r_length=6.7u
X47 a_16600_25606# a_15200_23484# VSS ppolyf_u_1k r_width=2u r_length=10u
X48 a_10300_18646# a_7500_23484# VSS ppolyf_u_1k r_width=2u r_length=6.7u
X49 a_10300_25606# a_10409_11499# VSS ppolyf_u_1k r_width=2u r_length=10u
X50 VSS a_6833_5969# a_6100_17184# VSS nfet_03v3 ad=1.78p pd=8.89u as=1.06p ps=4.53u w=4u l=0.28u
X51 a_6833_5969# D5 VSS VSS nfet_03v3 ad=0.445p pd=2.89u as=0.445p ps=2.89u w=1u l=0.28u
X52 a_1545_6179# a_1469_7509# VDD VDD pfet_03v3 ad=1.59p pd=6.53u as=1.59p ps=6.53u w=6u l=0.28u
X53 a_4700_19306# a_6100_17184# VSS ppolyf_u_1k r_width=2u r_length=10u
X54 a_7500_25606# a_7500_23484# VSS ppolyf_u_1k r_width=2u r_length=10u
X55 a_13100_23484# a_16600_17184# VSS ppolyf_u_1k r_width=2u r_length=6.7u
X56 a_4593_5969# D3 VSS VSS nfet_03v3 ad=0.445p pd=2.89u as=0.445p ps=2.89u w=1u l=0.28u
X57 a_2600_25606# a_2600_23484# VSS ppolyf_u_1k r_width=2u r_length=10u
X58 a_6585_1460# D1 VDD VDD pfet_03v3 ad=0.89p pd=4.89u as=0.89p ps=4.89u w=2u l=0.28u
X59 a_2600_23484# a_11700_17184# VSS ppolyf_u_1k r_width=2u r_length=6.7u
X60 a_13100_25606# a_14500_23484# VSS ppolyf_u_1k r_width=2u r_length=10u
X61 VDD a_4905_1460# a_6800_23484# VDD pfet_03v3 ad=1.59p pd=6.53u as=1.59p ps=6.53u w=6u l=0.28u
X62 VSS a_4269_7089# a_4345_6179# VSS nfet_03v3 ad=1.06p pd=4.53u as=1.06p ps=4.53u w=4u l=0.28u
X63 VSS a_1793_5969# a_1869_6179# VSS nfet_03v3 ad=1.78p pd=8.89u as=1.06p ps=4.53u w=4u l=0.28u
X64 a_1869_6179# a_1793_5969# VDD VDD pfet_03v3 ad=1.59p pd=6.53u as=1.59p ps=6.53u w=6u l=0.28u
X65 a_1869_6179# a_1793_5969# VDD VDD pfet_03v3 ad=1.59p pd=6.53u as=1.59p ps=6.53u w=6u l=0.28u
X66 VSS a_1469_7509# a_1545_6179# VSS nfet_03v3 ad=1.06p pd=4.53u as=1.06p ps=4.53u w=4u l=0.28u
X67 a_6100_12906# a_6800_11444# VSS ppolyf_u_1k r_width=2u r_length=6.7u
X68 a_2600_19306# a_4000_17184# VSS ppolyf_u_1k r_width=2u r_length=10u
X69 a_5400_25606# a_4000_23484# VSS ppolyf_u_1k r_width=2u r_length=10u
X70 a_1469_7509# D6 VDD VDD pfet_03v3 ad=0.89p pd=4.89u as=0.89p ps=4.89u w=2u l=0.28u
X71 a_1900_12906# a_1900_11444# VSS ppolyf_u_1k r_width=2u r_length=6.7u
X72 a_15900_25606# a_4669_6179# VSS ppolyf_u_1k r_width=2u r_length=10u
X73 VDD a_4905_1460# a_6800_23484# VDD pfet_03v3 ad=2.67p pd=12.89u as=1.59p ps=6.53u w=6u l=0.28u
X74 a_11000_18646# a_8200_23484# VSS ppolyf_u_1k r_width=2u r_length=6.7u
X75 a_11000_25606# a_4345_6179# VSS ppolyf_u_1k r_width=2u r_length=10u
X76 a_4269_7089# D2 VDD VDD pfet_03v3 ad=0.89p pd=4.89u as=0.89p ps=4.89u w=2u l=0.28u
X77 VDD a_1469_7509# a_1545_6179# VDD pfet_03v3 ad=2.67p pd=12.89u as=1.59p ps=6.53u w=6u l=0.28u
X78 a_6509_7089# D4 VDD VDD pfet_03v3 ad=0.89p pd=4.89u as=0.89p ps=4.89u w=2u l=0.28u
X79 a_1469_7509# D6 VSS VSS nfet_03v3 ad=0.445p pd=2.89u as=0.445p ps=2.89u w=1u l=0.28u
X80 VSS a_6509_7089# a_6585_6179# VSS nfet_03v3 ad=1.06p pd=4.53u as=1.06p ps=4.53u w=4u l=0.28u
X81 a_8900_19306# a_8200_17184# VSS ppolyf_u_1k r_width=2u r_length=10u
X82 a_4593_5969# D3 VDD VDD pfet_03v3 ad=0.89p pd=4.89u as=0.89p ps=4.89u w=2u l=0.28u
X83 a_10409_11499# a_6585_1460# VDD VDD pfet_03v3 ad=1.59p pd=6.53u as=1.59p ps=6.53u w=6u l=0.28u
X84 a_8200_25606# a_8200_23484# VSS ppolyf_u_1k r_width=2u r_length=10u
X85 a_4700_12906# a_3300_11444# VSS ppolyf_u_1k r_width=2u r_length=6.7u
X86 a_14500_18646# a_15900_17184# VSS ppolyf_u_1k r_width=2u r_length=6.7u
X87 a_4669_6179# a_4593_5969# VSS VSS nfet_03v3 ad=1.06p pd=4.53u as=1.06p ps=4.53u w=4u l=0.28u
X88 a_1900_25606# a_3300_23484# VSS ppolyf_u_1k r_width=2u r_length=10u
X89 a_1793_5969# D7 VDD VDD pfet_03v3 ad=0.89p pd=4.89u as=0.89p ps=4.89u w=2u l=0.28u
X90 VDD a_4269_7089# a_4345_6179# VDD pfet_03v3 ad=1.59p pd=6.53u as=1.59p ps=6.53u w=6u l=0.28u
X91 a_13800_25606# a_15200_23484# VSS ppolyf_u_1k r_width=2u r_length=10u
X92 a_10409_11499# a_6585_1460# VDD VDD pfet_03v3 ad=1.59p pd=6.53u as=1.59p ps=6.53u w=6u l=0.28u
X93 a_6800_23484# a_4905_1460# VDD VDD pfet_03v3 ad=1.59p pd=6.53u as=1.59p ps=6.53u w=6u l=0.28u
X94 a_10300_25606# a_8900_23484# VSS ppolyf_u_1k r_width=2u r_length=10u
X95 a_6833_5969# D5 VDD VDD pfet_03v3 ad=0.89p pd=4.89u as=0.89p ps=4.89u w=2u l=0.28u
X96 a_1793_5969# D7 VSS VSS nfet_03v3 ad=0.445p pd=2.89u as=0.445p ps=2.89u w=1u l=0.28u
X97 a_5400_19306# a_1545_6179# VSS ppolyf_u_1k r_width=2u r_length=10u
X98 a_4669_6179# a_4593_5969# VDD VDD pfet_03v3 ad=1.59p pd=6.53u as=1.59p ps=6.53u w=6u l=0.28u
X99 a_2600_11444# a_6800_11444# VSS ppolyf_u_1k r_width=2u r_length=6.7u
X100 a_1900_19306# a_1900_11444# VSS ppolyf_u_1k r_width=2u r_length=10u
X101 VDD a_4269_7089# a_4345_6179# VDD pfet_03v3 ad=2.67p pd=12.89u as=1.59p ps=6.53u w=6u l=0.28u
X102 a_2600_12906# a_2600_11444# VSS ppolyf_u_1k r_width=2u r_length=6.7u
X103 a_4700_25606# a_2600_23484# VSS ppolyf_u_1k r_width=2u r_length=10u
X104 VDD a_6509_7089# a_6585_6179# VDD pfet_03v3 ad=1.59p pd=6.53u as=1.59p ps=6.53u w=6u l=0.28u
X105 a_7500_23484# a_12400_17184# VSS ppolyf_u_1k r_width=2u r_length=6.7u
X106 a_6100_17184# a_6833_5969# VSS VSS nfet_03v3 ad=1.06p pd=4.53u as=1.06p ps=4.53u w=4u l=0.28u
X107 a_4669_6179# a_4593_5969# VDD VDD pfet_03v3 ad=1.59p pd=6.53u as=1.59p ps=6.53u w=6u l=0.28u
X108 a_16600_25606# a_6585_6179# VSS ppolyf_u_1k r_width=2u r_length=10u
X109 a_1545_6179# a_1469_7509# VDD VDD pfet_03v3 ad=1.59p pd=6.53u as=2.67p ps=12.89u w=6u l=0.28u
X110 a_13100_25606# a_13100_23484# VSS ppolyf_u_1k r_width=2u r_length=10u
X111 VDD a_6585_1460# a_10409_11499# VDD pfet_03v3 ad=1.59p pd=6.53u as=1.59p ps=6.53u w=6u l=0.28u
X112 a_6800_23484# a_4905_1460# VDD VDD pfet_03v3 ad=1.59p pd=6.53u as=2.67p ps=12.89u w=6u l=0.28u
X113 a_8900_19306# a_1869_6179# VSS ppolyf_u_1k r_width=2u r_length=10u
X114 VSS a_4905_1460# a_6800_23484# VSS nfet_03v3 ad=1.06p pd=4.53u as=1.06p ps=4.53u w=4u l=0.28u
X115 VDD a_6585_1460# a_10409_11499# VDD pfet_03v3 ad=1.59p pd=6.53u as=1.59p ps=6.53u w=6u l=0.28u
X116 a_6585_6179# a_6509_7089# VSS VSS nfet_03v3 ad=1.06p pd=4.53u as=1.78p ps=8.89u w=4u l=0.28u
X117 a_4700_19306# a_3300_17184# VSS ppolyf_u_1k r_width=2u r_length=10u
X118 VDD a_6509_7089# a_6585_6179# VDD pfet_03v3 ad=2.67p pd=12.89u as=1.59p ps=6.53u w=6u l=0.28u
X119 a_1900_11444# a_4000_11444# VSS ppolyf_u_1k r_width=2u r_length=6.7u
X120 a_15200_18646# a_16600_17184# VSS ppolyf_u_1k r_width=2u r_length=6.7u
C0 D5 D3 1.15035f
C1 a_4905_1460# a_6509_7089# 0.14612f
C2 a_4669_6179# a_10409_11499# 0.17591f
C3 a_8200_17184# a_1869_6179# 0.03959f
C4 a_6585_1460# a_1469_7509# 0.03776f
C5 a_4269_7089# D1 0.15561f
C6 a_6585_6179# a_4345_6179# 0.93521f
C7 a_1545_6179# D4 0.0577f
C8 a_6100_12906# OUT 0.01802f
C9 a_4593_5969# D0 0.08703f
C10 D3 D6 0.08961f
C11 a_1469_7509# a_1793_5969# 0.12397f
C12 a_10300_18646# a_8200_23484# 0.02636f
C13 a_6800_23484# a_6100_17184# 1.89405f
C14 a_1545_6179# a_4669_6179# 0.03601f
C15 D7 a_1900_12906# 0.01554f
C16 a_1545_6179# D2 0.1349f
C17 VDD D7 3.32312f
C18 D4 a_2600_11444# 0.04275f
C19 D7 a_1869_6179# 0.04359f
C20 VDD a_6509_7089# 3.93337f
C21 a_6509_7089# a_1869_6179# 0.46264f
C22 a_8200_23484# a_4345_6179# 0.04457f
C23 a_1284_6119# a_1469_7509# 0.01348f
C24 a_2600_23484# VDD 0.2302f
C25 VDD a_4644_1400# 0.36569f
C26 a_11368_11439# a_10409_11499# 0.01484f
C27 a_4269_7089# D7 0.10561f
C28 VDD a_11774_1400# 0.34967f
C29 a_6585_1460# D1 0.85644f
C30 a_4269_7089# a_6509_7089# 0.69202f
C31 a_6833_5969# D0 0.03654f
C32 a_12624_11439# a_4345_6179# 0.01212f
C33 D1 a_1793_5969# 0.06739f
C34 a_8200_23484# a_4700_12906# 0.05414f
C35 a_4700_12906# a_4345_6179# 0.04457f
C36 a_6585_6179# a_10409_11499# 0.04913f
C37 D4 a_4593_5969# 0.12843f
C38 a_6100_12906# a_6800_23484# 0.01073f
C39 a_5054_1400# a_4905_1460# 0.02481f
C40 a_1545_6179# D5 1.308f
C41 a_4905_1460# D0 0.28131f
C42 a_10300_18646# a_10409_11499# 0.06165f
C43 a_6585_1460# a_12894_6222# 0.01149f
C44 a_4593_5969# a_4669_6179# 0.3524f
C45 a_4593_5969# D2 0.39324f
C46 a_1545_6179# D6 0.0954f
C47 a_1545_6179# a_6585_6179# 0.10073f
C48 a_6585_1460# D7 0.14457f
C49 a_8200_23484# a_10409_11499# 0.1483f
C50 a_6585_1460# a_6509_7089# 0.16096f
C51 a_4345_6179# a_10409_11499# 0.06626f
C52 a_10300_25606# a_11000_25606# 0.23983f
C53 a_5054_1400# VDD 0.34678f
C54 D7 a_1793_5969# 0.23493f
C55 a_6509_7089# a_1793_5969# 0.91952f
C56 a_6833_5969# D4 0.10765f
C57 a_3300_17184# a_4000_17184# 0.23983f
C58 VDD D0 1.43961f
C59 a_7500_23484# a_10300_18646# 0.12999f
C60 a_6800_23484# a_8100_11444# 0.01122f
C61 a_12624_11439# a_10409_11499# 0.01416f
C62 a_1545_6179# a_4345_6179# 0.06426f
C63 a_4980_6119# a_4669_6179# 0.01367f
C64 a_4700_12906# a_10409_11499# 0.04457f
C65 a_5400_19306# a_4700_19306# 0.23983f
C66 a_6100_17184# a_1469_7509# 0.04129f
C67 a_6833_5969# D2 0.03322f
C68 D5 a_4593_5969# 0.07058f
C69 a_7500_23484# a_8200_23484# 0.32191f
C70 a_6100_12906# a_6100_17184# 0.01942f
C71 a_7500_23484# a_4345_6179# 0.04359f
C72 a_4269_7089# D0 0.54935f
C73 a_4905_1460# D4 0.06754f
C74 a_1545_6179# a_4700_12906# 0.03696f
C75 a_4593_5969# D6 0.03995f
C76 a_1694_1742# a_1469_7509# 0.0139f
C77 a_4905_1460# a_4669_6179# 1.50738f
C78 a_1900_11444# D7 0.03791f
C79 a_4905_1460# D2 0.06069f
C80 a_6800_23484# a_6509_7089# 0.03351f
C81 D4 a_9460_6119# 0.01133f
C82 a_7500_23484# a_4700_12906# 0.1358f
C83 a_5400_25606# a_4700_25606# 0.23983f
C84 a_4700_12906# a_12400_17184# 0.0453f
C85 a_2600_11444# a_2600_12906# 0.09434f
C86 a_2600_23484# a_6800_23484# 0.06667f
C87 a_2600_11444# a_4700_12906# 0.05486f
C88 a_6833_5969# a_13454_1400# 0.01988f
C89 a_2600_23484# a_13100_23484# 0.57889f
C90 D4 VDD 1.60368f
C91 VDD a_11364_1400# 0.36295f
C92 a_6833_5969# D5 0.13861f
C93 a_13100_23484# a_15200_18646# 0.02028f
C94 D4 a_1869_6179# 1.80592f
C95 a_6585_1460# D0 0.11565f
C96 a_4593_5969# a_4345_6179# 0.05582f
C97 a_6100_17184# a_8100_11444# 0.01122f
C98 VDD a_4669_6179# 3.02426f
C99 VDD D2 1.16839f
C100 a_1869_6179# a_4669_6179# 0.11594f
C101 a_4593_5969# D3 2.16159f
C102 a_6833_5969# D6 0.0427f
C103 a_4269_7089# D4 0.1996f
C104 a_1869_6179# D2 0.96965f
C105 a_6833_5969# a_6585_6179# 0.05818f
C106 D0 a_1793_5969# 0.14127f
C107 a_7500_23484# a_10409_11499# 0.04269f
C108 a_15134_1400# a_1469_7509# 0.01988f
C109 D5 a_4905_1460# 0.03177f
C110 VDD a_14724_1400# 0.36295f
C111 a_4269_7089# a_4669_6179# 0.19367f
C112 a_16600_17184# a_15900_17184# 0.23983f
C113 a_4269_7089# D2 0.17075f
C114 a_2600_25606# a_1900_25606# 0.23983f
C115 a_4905_1460# D6 0.03474f
C116 a_15424_11439# a_6509_7089# 0.01298f
C117 a_4905_1460# a_6585_6179# 0.11001f
C118 a_1545_6179# a_6800_11444# 0.02227f
C119 D1 a_1469_7509# 0.04212f
C120 a_6100_17184# a_6509_7089# 0.1914f
C121 a_1545_6179# a_2600_11444# 0.03901f
C122 VDD a_13454_1400# 0.34967f
C123 VDD a_11368_11439# 0.89462f
C124 a_6833_5969# D3 0.30669f
C125 D5 VDD 1.24317f
C126 OUT D4 0.0723f
C127 a_6585_1460# D4 0.12718f
C128 D5 a_1869_6179# 0.0185f
C129 D4 a_1793_5969# 0.05698f
C130 a_4905_1460# a_4345_6179# 0.07067f
C131 OUT a_4669_6179# 0.12565f
C132 VDD D6 3.41706f
C133 VDD a_6585_6179# 3.72879f
C134 a_6585_1460# D2 0.06656f
C135 a_1869_6179# D6 0.04295f
C136 a_1869_6179# a_6585_6179# 0.07555f
C137 D5 a_4269_7089# 0.76278f
C138 a_13800_25606# a_13100_25606# 0.23983f
C139 a_4905_1460# D3 0.0308f
C140 D7 a_1469_7509# 0.14775f
C141 a_18600_17184# a_13100_23484# 0.01061f
C142 a_6509_7089# a_1469_7509# 0.91799f
C143 D6 a_1300_17184# 0.07964f
C144 a_1793_5969# D2 0.08377f
C145 a_4269_7089# D6 0.51412f
C146 a_4269_7089# a_6585_6179# 0.05003f
C147 a_1545_6179# a_8564_6119# 0.0176f
C148 VDD a_8200_23484# 0.33039f
C149 VDD a_4345_6179# 3.39071f
C150 a_1869_6179# a_4345_6179# 0.09137f
C151 a_1793_5969# a_3374_1742# 0.01149f
C152 VDD D3 1.13982f
C153 a_6800_23484# D4 0.06316f
C154 D4 a_1900_11444# 0.04245f
C155 D5 a_6585_1460# 0.03678f
C156 a_1900_12906# a_2600_12906# 0.23983f
C157 a_15200_23484# a_14500_23484# 0.23983f
C158 a_4269_7089# a_4345_6179# 0.73648f
C159 a_12624_11439# VDD 0.89462f
C160 D7 D1 0.26218f
C161 a_6833_5969# a_1545_6179# 0.01339f
C162 a_4905_1460# a_10409_11499# 1.32038f
C163 VDD a_4700_12906# 0.66078f
C164 a_6509_7089# D1 0.05576f
C165 D5 a_1793_5969# 0.04058f
C166 a_1869_6179# a_4700_12906# 0.20328f
C167 a_4000_11444# a_3300_11444# 0.23983f
C168 a_6800_23484# a_4669_6179# 0.14248f
C169 a_4269_7089# D3 0.03335f
C170 OUT a_6585_6179# 0.04038f
C171 a_13100_23484# a_4669_6179# 0.03204f
C172 a_6585_1460# D6 0.02918f
C173 a_6585_1460# a_6585_6179# 0.62723f
C174 a_5400_19306# a_6800_23484# 0.03293f
C175 a_12624_11439# a_4269_7089# 0.01071f
C176 D6 a_1793_5969# 0.38672f
C177 a_4269_7089# a_14574_6222# 0.01151f
C178 a_9824_11439# a_4905_1460# 0.01348f
C179 VDD a_10409_11499# 3.00716f
C180 D0 a_1469_7509# 0.05693f
C181 OUT a_4345_6179# 0.20982f
C182 a_13100_23484# a_14500_18646# 0.05154f
C183 a_6509_7089# D7 0.10864f
C184 a_6800_23484# a_11368_11439# 0.01232f
C185 VDD a_13044_1400# 0.36295f
C186 a_6585_1460# D3 0.03814f
C187 a_3300_11444# D7 0.02449f
C188 a_6100_17184# D4 0.06316f
C189 a_2600_23484# D7 0.04457f
C190 a_4269_7089# a_10409_11499# 0.13103f
C191 a_6833_5969# a_4593_5969# 0.15761f
C192 a_1545_6179# VDD 2.69837f
C193 a_1545_6179# a_1869_6179# 0.34262f
C194 a_4000_17184# a_4700_12906# 0.06749f
C195 D3 a_1793_5969# 0.34091f
C196 OUT a_4700_12906# 0.30606f
C197 a_3300_17184# D7 0.02449f
C198 a_6509_7089# a_11774_1400# 0.01988f
C199 a_9824_11439# VDD 0.89462f
C200 a_1900_11444# D6 0.47722f
C201 D7 a_1300_23484# 0.0308f
C202 a_2600_23484# a_8900_23484# 0.026f
C203 a_6100_17184# a_4669_6179# 2.06576f
C204 a_6800_23484# a_6585_6179# 0.75166f
C205 a_6100_17184# D2 0.01096f
C206 a_7500_23484# VDD 0.33039f
C207 a_6585_6179# a_13100_23484# 0.11444f
C208 a_7500_23484# a_1869_6179# 0.0127f
C209 a_2600_11444# a_1900_12906# 0.02248f
C210 a_3300_23484# D7 0.02449f
C211 a_1545_6179# a_4269_7089# 0.65423f
C212 VDD a_2600_11444# 0.3264f
C213 a_4905_1460# a_4593_5969# 0.03566f
C214 D1 D0 0.04209f
C215 D7 a_1900_19306# 0.01554f
C216 a_3300_23484# a_2600_23484# 0.03222f
C217 D4 a_1469_7509# 0.07787f
C218 OUT a_10409_11499# 0.0371f
C219 a_6585_1460# a_10409_11499# 0.35722f
C220 a_6800_23484# a_4345_6179# 1.27134f
C221 a_8200_23484# a_13100_23484# 0.89372f
C222 a_4345_6179# a_13100_23484# 0.0545f
C223 a_1469_7509# a_4669_6179# 0.04194f
C224 a_10300_18646# a_11000_18646# 0.23983f
C225 a_1469_7509# D2 0.58028f
C226 VDD a_4593_5969# 2.62696f
C227 a_1900_11444# a_2600_12906# 0.02004f
C228 a_1545_6179# OUT 0.08898f
C229 a_15900_17184# a_4669_6179# 0.05939f
C230 a_6800_23484# a_4700_12906# 0.03234f
C231 a_1900_11444# a_4700_12906# 0.03386f
C232 a_8200_23484# a_11000_18646# 0.01924f
C233 a_6833_5969# a_4905_1460# 0.01633f
C234 a_15424_11439# a_6585_6179# 0.01161f
C235 a_1469_7509# a_14724_1400# 0.01039f
C236 D7 D0 0.65996f
C237 a_4700_12906# a_13100_23484# 0.08752f
C238 a_6100_17184# a_6585_6179# 0.39062f
C239 a_6509_7089# D0 0.04302f
C240 a_1545_6179# a_1793_5969# 0.27774f
C241 a_4269_7089# a_4593_5969# 0.6218f
C242 D4 D1 0.21111f
C243 OUT a_2600_11444# 0.03901f
C244 D5 a_1469_7509# 0.0866f
C245 D1 D2 0.09386f
C246 a_6800_23484# a_10409_11499# 0.31954f
C247 a_6833_5969# VDD 2.63082f
C248 a_6100_17184# a_4345_6179# 0.68122f
C249 a_8100_11444# a_4669_6179# 0.02101f
C250 a_1469_7509# D6 0.84568f
C251 a_1469_7509# a_6585_6179# 0.05448f
C252 a_6585_1460# a_4593_5969# 0.98471f
C253 a_1545_6179# a_6800_23484# 1.07284f
C254 D4 D7 0.28795f
C255 a_4905_1460# VDD 4.24018f
C256 D4 a_6509_7089# 0.21526f
C257 a_6509_7089# a_11364_1400# 0.01039f
C258 a_6100_17184# a_4700_12906# 0.03998f
C259 a_9824_11439# a_6800_23484# 0.01173f
C260 a_4593_5969# a_1793_5969# 0.84325f
C261 a_7500_23484# a_6800_23484# 0.01368f
C262 VDD a_8414_1400# 0.34967f
C263 a_16600_17184# a_6585_6179# 0.02449f
C264 a_7500_23484# a_13100_23484# 0.06326f
C265 D7 D2 0.25728f
C266 a_2600_11444# a_1900_11444# 1.10973f
C267 D5 D1 0.03775f
C268 a_6800_23484# a_2600_11444# 0.04822f
C269 a_6509_7089# a_4669_6179# 0.03696f
C270 a_4905_1460# a_4269_7089# 1.04333f
C271 a_6509_7089# D2 0.28127f
C272 a_1469_7509# a_4345_6179# 0.03672f
C273 D3 a_1469_7509# 0.06791f
C274 a_4269_7089# a_8414_1400# 0.01988f
C275 D1 D6 0.07879f
C276 a_1545_6179# a_2828_6119# 0.01223f
C277 VDD a_1869_6179# 2.24103f
C278 a_7500_23484# a_11000_18646# 0.0469f
C279 a_6100_17184# a_10409_11499# 0.04379f
C280 a_16968_11439# a_6585_6179# 0.01154f
C281 a_6833_5969# a_6585_1460# 0.20079f
C282 a_8100_11444# a_6585_6179# 0.03043f
C283 a_6833_5969# a_1793_5969# 0.11567f
C284 a_4269_7089# VDD 3.95883f
C285 a_4269_7089# a_1869_6179# 0.12035f
C286 D5 D7 0.17548f
C287 a_1545_6179# a_6100_17184# 0.10676f
C288 a_4905_1460# a_6585_1460# 0.54518f
C289 D5 a_6509_7089# 0.38767f
C290 a_14500_18646# a_15200_18646# 0.23983f
C291 a_9684_1400# VDD 0.36295f
C292 D3 D1 0.26125f
C293 a_8100_11444# a_4345_6179# 0.01759f
C294 a_4905_1460# a_1793_5969# 0.99047f
C295 D7 D6 0.35529f
C296 a_6100_17184# a_2600_11444# 0.03901f
C297 a_6509_7089# D6 0.04179f
C298 a_6509_7089# a_6585_6179# 0.56204f
C299 D4 D0 0.26664f
C300 a_4593_5969# a_10094_1400# 0.01988f
C301 OUT VDD 3.44707f
C302 OUT a_1869_6179# 0.03481f
C303 a_6585_1460# VDD 2.91781f
C304 VDD a_8004_1400# 0.36295f
C305 a_1545_6179# a_1469_7509# 0.48265f
C306 VDD a_6734_1400# 0.34678f
C307 D0 D2 0.08457f
C308 a_11700_17184# a_4345_6179# 0.05055f
C309 a_8200_17184# a_4700_12906# 0.02277f
C310 a_6100_12906# a_1545_6179# 0.02056f
C311 VDD a_1793_5969# 2.7068f
C312 a_1869_6179# a_1793_5969# 0.35296f
C313 a_6585_1460# a_4269_7089# 0.23461f
C314 D7 D3 0.18417f
C315 a_2600_23484# a_8200_23484# 0.06246f
C316 a_4269_7089# a_8004_1400# 0.01012f
C317 a_2600_23484# a_4345_6179# 1.05198f
C318 a_8200_23484# a_15200_18646# 0.01103f
C319 a_4905_1460# a_6800_23484# 0.55078f
C320 a_1900_19306# D6 0.01018f
C321 a_6509_7089# D3 0.14172f
C322 a_11700_17184# a_4700_12906# 0.061f
C323 D7 a_2600_12906# 0.042f
C324 a_6100_12906# a_2600_11444# 0.02982f
C325 a_4269_7089# a_1793_5969# 0.129f
C326 VDD a_16814_1400# 0.35048f
C327 VDD a_1284_6119# 0.89462f
C328 D5 D0 0.03188f
C329 VDD a_14168_11439# 0.89462f
C330 a_1900_11444# a_1900_12906# 0.03417f
C331 D4 a_4669_6179# 0.03234f
C332 D4 D2 0.21872f
C333 VDD a_1900_11444# 0.32241f
C334 a_6800_23484# VDD 2.93676f
C335 a_6800_23484# a_1869_6179# 0.02568f
C336 a_4593_5969# a_1469_7509# 0.0744f
C337 a_11700_17184# a_10409_11499# 0.03293f
C338 a_6833_5969# a_6100_17184# 0.35506f
C339 VDD a_13100_23484# 0.30438f
C340 D0 D6 0.70871f
C341 a_8200_25606# a_7500_25606# 0.23983f
C342 a_8200_23484# a_7500_19306# 0.01966f
C343 a_6585_1460# a_6734_1400# 0.02481f
C344 a_2600_23484# a_9600_23484# 0.06409f
C345 a_8900_23484# a_9600_23484# 0.23983f
C346 a_6509_7089# a_10409_11499# 0.06898f
C347 a_4669_6179# D2 0.01883f
C348 a_6585_1460# a_1793_5969# 0.95245f
C349 a_6800_23484# a_4269_7089# 0.02786f
C350 a_2600_23484# a_10409_11499# 0.05299f
C351 a_4905_1460# a_6100_17184# 0.0523f
C352 a_1545_6179# D7 0.03755f
C353 D7 a_2600_19306# 0.042f
C354 VDD a_10094_1400# 0.34967f
C355 a_1545_6179# a_6509_7089# 0.08204f
C356 a_15900_25606# a_16600_25606# 0.23983f
C357 a_11700_17184# a_12400_17184# 0.23983f
C358 VDD a_2828_6119# 0.89462f
C359 a_2828_6119# a_1869_6179# 0.01176f
C360 D5 D4 0.40733f
C361 a_6800_23484# a_18224_11439# 0.01814f
C362 a_6833_5969# a_1469_7509# 0.03102f
C363 D3 D0 0.0721f
C364 a_4593_5969# D1 0.07613f
C365 a_1793_5969# a_16814_1400# 0.01988f
C366 a_2600_11444# D7 0.03791f
C367 a_15424_11439# VDD 0.89462f
C368 a_7500_23484# a_2600_23484# 0.1169f
C369 D4 D6 0.10489f
C370 D4 a_6585_6179# 0.03234f
C371 D5 D2 2.93522f
C372 OUT a_6800_23484# 0.07318f
C373 a_1300_11444# D6 0.05622f
C374 a_6100_17184# VDD 2.49119f
C375 a_6585_1460# a_6800_23484# 0.04071f
C376 a_6100_17184# a_1869_6179# 0.07935f
C377 a_4905_1460# a_1469_7509# 0.03963f
C378 VDD a_6324_1400# 0.36583f
C379 a_6585_6179# a_4669_6179# 0.03536f
C380 D6 D2 0.09225f
C381 a_6585_6179# D2 0.05144f
C382 a_1900_19306# a_2600_19306# 0.23983f
C383 a_6100_17184# a_4269_7089# 0.02932f
C384 a_4593_5969# D7 0.15201f
C385 a_6833_5969# D1 0.9164f
C386 D4 a_4345_6179# 0.02568f
C387 VDD a_16404_1400# 0.36281f
C388 a_6509_7089# a_4593_5969# 0.1475f
C389 a_2600_23484# a_4000_23484# 0.07132f
C390 D4 D3 0.25102f
C391 a_7500_23484# a_7500_19306# 0.02551f
C392 VDD a_1469_7509# 4.04827f
C393 a_8200_23484# a_4669_6179# 0.13596f
C394 a_1869_6179# a_1469_7509# 0.51721f
C395 a_4345_6179# a_4669_6179# 1.48195f
C396 a_4345_6179# D2 0.05275f
C397 a_4905_1460# D1 0.03851f
C398 D4 a_4700_12906# 0.04305f
C399 D3 D2 0.47264f
C400 a_3300_23484# a_4000_23484# 0.23983f
C401 D5 D6 0.10551f
C402 D5 a_6585_6179# 0.08285f
C403 a_6833_5969# a_19614_6222# 0.01149f
C404 a_4269_7089# a_1469_7509# 0.18701f
C405 OUT a_6100_17184# 1.28539f
C406 a_6509_7089# a_17934_6222# 0.01149f
C407 VDD a_15134_1400# 0.34967f
C408 a_6833_5969# D7 0.15201f
C409 a_6833_5969# a_6509_7089# 0.56735f
C410 a_8200_23484# a_14500_18646# 0.01041f
C411 VDD D1 1.03532f
C412 VDD a_16968_11439# 0.89462f
C413 D5 a_4345_6179# 0.09139f
C414 a_4905_1460# a_11214_6222# 0.01149f
C415 a_4593_5969# a_16254_6222# 0.01149f
C416 a_4905_1460# D7 0.15139f
C417 D7 VSS 12.5432f
C418 D6 VSS 9.70059f
C419 D5 VSS 7.62762f
C420 D4 VSS 9.89215f
C421 D3 VSS 7.35716f
C422 D2 VSS 3.55914f
C423 D1 VSS 7.33589f
C424 D0 VSS 4.85088f
C425 OUT VSS 5.25924f
C426 VDD VSS 0.16259p
C427 a_16814_1400# VSS 0.04368f
C428 a_16404_1400# VSS 0.04368f
C429 a_15134_1400# VSS 0.04368f
C430 a_14724_1400# VSS 0.04368f
C431 a_13454_1400# VSS 0.04368f
C432 a_13044_1400# VSS 0.04368f
C433 a_11774_1400# VSS 0.04368f
C434 a_11364_1400# VSS 0.04368f
C435 a_10094_1400# VSS 0.04368f
C436 a_9684_1400# VSS 0.04368f
C437 a_8414_1400# VSS 0.04368f
C438 a_8004_1400# VSS 0.04368f
C439 a_6734_1400# VSS 0.04368f
C440 a_6324_1400# VSS 0.04368f
C441 a_5054_1400# VSS 0.04368f
C442 a_4644_1400# VSS 0.04368f
C443 a_3374_1742# VSS 0.24275f
C444 a_2964_1742# VSS 0.25096f ; **FLOATING
C445 a_1694_1742# VSS 0.24275f
C446 a_1284_1742# VSS 0.25327f ; **FLOATING
C447 a_19614_6222# VSS 0.24358f
C448 a_19204_6222# VSS 0.25096f ; **FLOATING
C449 a_17934_6222# VSS 0.24358f
C450 a_17524_6222# VSS 0.25096f ; **FLOATING
C451 a_16254_6222# VSS 0.24275f
C452 a_15844_6222# VSS 0.25096f ; **FLOATING
C453 a_14574_6222# VSS 0.24275f
C454 a_14164_6222# VSS 0.25096f ; **FLOATING
C455 a_12894_6222# VSS 0.24275f
C456 a_12484_6222# VSS 0.25096f ; **FLOATING
C457 a_11214_6222# VSS 0.24275f
C458 a_10804_6222# VSS 0.25096f ; **FLOATING
C459 a_9460_6119# VSS 0.73005f
C460 a_8564_6119# VSS 0.72843f
C461 a_7220_6119# VSS 0.72946f ; **FLOATING
C462 a_6324_6119# VSS 0.73261f ; **FLOATING
C463 a_4980_6119# VSS 0.72786f
C464 a_4084_6119# VSS 0.73111f ; **FLOATING
C465 a_2828_6119# VSS 0.14277f
C466 a_1793_5969# VSS 5.05829f ; **FLOATING
C467 a_1284_6119# VSS 0.14277f
C468 a_1469_7509# VSS 6.95951f ; **FLOATING
C469 a_19120_11439# VSS 0.73261f ; **FLOATING
C470 a_18224_11439# VSS 0.72843f
C471 a_16968_11439# VSS 0.14277f
C472 a_6833_5969# VSS 9.60884f ; **FLOATING
C473 a_15424_11439# VSS 0.14277f
C474 a_6509_7089# VSS 5.77533f ; **FLOATING
C475 a_14168_11439# VSS 0.14277f
C476 a_4593_5969# VSS 5.22861f ; **FLOATING
C477 a_12624_11439# VSS 0.14277f
C478 a_4269_7089# VSS 5.5103f ; **FLOATING
C479 a_11368_11439# VSS 0.14277f
C480 a_6585_1460# VSS 5.4115f ; **FLOATING
C481 a_9824_11439# VSS 0.14277f
C482 a_4905_1460# VSS 5.56935f ; **FLOATING
C483 a_8100_11444# VSS 2.89452f
C484 a_6800_11444# VSS 1.16946f ; **FLOATING
C485 a_6100_12906# VSS 1.16914f ; **FLOATING
C486 a_4000_11444# VSS 1.38984f ; **FLOATING
C487 a_3300_11444# VSS 1.39452f ; **FLOATING
C488 a_2600_12906# VSS 1.38984f ; **FLOATING
C489 a_1900_12906# VSS 1.39175f ; **FLOATING
C490 a_1300_11444# VSS 2.89452f
C491 a_18600_17184# VSS 4.01171f
C492 a_16600_17184# VSS 1.39175f ; **FLOATING
C493 a_15900_17184# VSS 1.39566f ; **FLOATING
C494 a_15200_18646# VSS 1.39617f ; **FLOATING
C495 a_14500_18646# VSS 1.435f ; **FLOATING
C496 a_12400_17184# VSS 1.39222f ; **FLOATING
C497 a_11700_17184# VSS 1.39441f ; **FLOATING
C498 a_11000_18646# VSS 1.39617f ; **FLOATING
C499 a_10300_18646# VSS 1.27008f ; **FLOATING
C500 a_1869_6179# VSS 4.95504f ; **FLOATING
C501 a_8900_19306# VSS 1.17979f ; **FLOATING
C502 a_8200_17184# VSS 1.17717f ; **FLOATING
C503 a_7500_19306# VSS 1.16914f ; **FLOATING
C504 a_1545_6179# VSS 5.09246f ; **FLOATING
C505 a_6100_17184# VSS 4.00478f ; **FLOATING
C506 a_5400_19306# VSS 1.38984f ; **FLOATING
C507 a_4700_19306# VSS 1.39143f ; **FLOATING
C508 a_4000_17184# VSS 1.39592f ; **FLOATING
C509 a_3300_17184# VSS 1.39452f ; **FLOATING
C510 a_2600_11444# VSS 4.37454f ; **FLOATING
C511 a_2600_19306# VSS 1.38984f ; **FLOATING
C512 a_1900_11444# VSS 3.18261f ; **FLOATING
C513 a_1900_19306# VSS 1.39175f ; **FLOATING
C514 a_1300_17184# VSS 4.01171f
C515 a_18600_23484# VSS 4.01171f ; **FLOATING
C516 a_6585_6179# VSS 8.78829f ; **FLOATING
C517 a_4669_6179# VSS 7.45468f ; **FLOATING
C518 a_16600_25606# VSS 1.38972f ; **FLOATING
C519 a_15900_25606# VSS 1.39143f ; **FLOATING
C520 a_15200_23484# VSS 1.39592f ; **FLOATING
C521 a_14500_23484# VSS 1.39452f ; **FLOATING
C522 a_4700_12906# VSS 8.79352f ; **FLOATING
C523 a_13800_25606# VSS 1.38984f ; **FLOATING
C524 a_13100_23484# VSS 4.33059f ; **FLOATING
C525 a_13100_25606# VSS 1.39143f ; **FLOATING
C526 a_4345_6179# VSS 5.72645f ; **FLOATING
C527 a_10409_11499# VSS 6.83286f ; **FLOATING
C528 a_11000_25606# VSS 1.38984f ; **FLOATING
C529 a_10300_25606# VSS 1.39143f ; **FLOATING
C530 a_9600_23484# VSS 1.39441f ; **FLOATING
C531 a_8900_23484# VSS 1.39742f ; **FLOATING
C532 a_8200_23484# VSS 6.03173f ; **FLOATING
C533 a_8200_25606# VSS 1.38984f ; **FLOATING
C534 a_7500_23484# VSS 6.02431f ; **FLOATING
C535 a_7500_25606# VSS 1.39143f ; **FLOATING
C536 a_6800_23484# VSS 5.15302f ; **FLOATING
C537 a_5400_25606# VSS 1.38984f ; **FLOATING
C538 a_4700_25606# VSS 1.39143f ; **FLOATING
C539 a_4000_23484# VSS 1.39592f ; **FLOATING
C540 a_3300_23484# VSS 1.39452f ; **FLOATING
C541 a_2600_23484# VSS 5.47594f ; **FLOATING
C542 a_2600_25606# VSS 1.38984f ; **FLOATING
C543 a_1900_25606# VSS 1.39175f ; **FLOATING
C544 a_1300_23484# VSS 4.0299f
.ends
