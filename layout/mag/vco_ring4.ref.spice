.subckt vco_core L1P L1N L2P L2N L3P L3N L4P L4N CK ckdn1 ckdp2 ckdn2 ckdp3 ckdn3 ckdp4 ckdn4 kh kl VR VSS
XMNa1 n1 p4 VSS VSS nfet_03v3 L=0.28u W=16u nf=4  m=1
XMNb1 p1 n4 VSS VSS nfet_03v3 L=0.28u W=16u nf=4  m=1
XMPa1 n1 p4 VR VR pfet_03v3 L=0.28u W=24u nf=8  m=1
XMPb1 p1 n4 VR VR pfet_03v3 L=0.28u W=24u nf=8  m=1
XMNc1 n1 p1 VSS VSS nfet_03v3 L=0.28u W=6u nf=2  m=1
XMNd1 p1 n1 VSS VSS nfet_03v3 L=0.28u W=6u nf=2  m=1
XMPc1 n1 p1 VR VR pfet_03v3 L=0.28u W=12u nf=4  m=1
XMPd1 p1 n1 VR VR pfet_03v3 L=0.28u W=12u nf=4  m=1
XMNa2 n2 p1 VSS VSS nfet_03v3 L=0.28u W=16u nf=4  m=1
XMNb2 p2 n1 VSS VSS nfet_03v3 L=0.28u W=16u nf=4  m=1
XMPa2 n2 p1 VR VR pfet_03v3 L=0.28u W=24u nf=8  m=1
XMPb2 p2 n1 VR VR pfet_03v3 L=0.28u W=24u nf=8  m=1
XMNc2 n2 p2 VSS VSS nfet_03v3 L=0.28u W=6u nf=2  m=1
XMNd2 p2 n2 VSS VSS nfet_03v3 L=0.28u W=6u nf=2  m=1
XMPc2 n2 p2 VR VR pfet_03v3 L=0.28u W=12u nf=4  m=1
XMPd2 p2 n2 VR VR pfet_03v3 L=0.28u W=12u nf=4  m=1
XMNa3 n3 p2 VSS VSS nfet_03v3 L=0.28u W=16u nf=4  m=1
XMNb3 p3 n2 VSS VSS nfet_03v3 L=0.28u W=16u nf=4  m=1
XMPa3 n3 p2 VR VR pfet_03v3 L=0.28u W=24u nf=8  m=1
XMPb3 p3 n2 VR VR pfet_03v3 L=0.28u W=24u nf=8  m=1
XMNc3 n3 p3 VSS VSS nfet_03v3 L=0.28u W=6u nf=2  m=1
XMNd3 p3 n3 VSS VSS nfet_03v3 L=0.28u W=6u nf=2  m=1
XMPc3 n3 p3 VR VR pfet_03v3 L=0.28u W=12u nf=4  m=1
XMPd3 p3 n3 VR VR pfet_03v3 L=0.28u W=12u nf=4  m=1
XMNa4 p4 p3 VSS VSS nfet_03v3 L=0.28u W=16u nf=4  m=1
XMNb4 n4 n3 VSS VSS nfet_03v3 L=0.28u W=16u nf=4  m=1
XMPa4 p4 p3 VR VR pfet_03v3 L=0.28u W=24u nf=8  m=1
XMPb4 n4 n3 VR VR pfet_03v3 L=0.28u W=24u nf=8  m=1
XMNc4 p4 n4 VSS VSS nfet_03v3 L=0.28u W=6u nf=2  m=1
XMNd4 n4 p4 VSS VSS nfet_03v3 L=0.28u W=6u nf=2  m=1
XMPc4 p4 n4 VR VR pfet_03v3 L=0.28u W=12u nf=4  m=1
XMPd4 n4 p4 VR VR pfet_03v3 L=0.28u W=12u nf=4  m=1
XMBNp1 ap1 p1 VSS VSS nfet_03v3 L=0.28u W=2u nf=1  m=1
XMBPp1 ap1 p1 VR VR pfet_03v3 L=0.28u W=4u nf=1  m=1
XMDNp1 L1P ap1 VSS VSS nfet_03v3 L=0.28u W=12u nf=4  m=1
XMDPp1 L1P ap1 VR VR pfet_03v3 L=0.28u W=24u nf=8  m=1
XMCNp1 CK L1P VSS VSS nfet_03v3 L=0.28u W=2u nf=1  m=1
XMCPp1 CK L1P VR VR pfet_03v3 L=0.28u W=4u nf=1  m=1
XMBNn1 an1 n1 VSS VSS nfet_03v3 L=0.28u W=2u nf=1  m=1
XMBPn1 an1 n1 VR VR pfet_03v3 L=0.28u W=4u nf=1  m=1
XMDNn1 L1N an1 VSS VSS nfet_03v3 L=0.28u W=12u nf=4  m=1
XMDPn1 L1N an1 VR VR pfet_03v3 L=0.28u W=24u nf=8  m=1
XMCNn1 ckdn1 L1N VSS VSS nfet_03v3 L=0.28u W=2u nf=1  m=1
XMCPn1 ckdn1 L1N VR VR pfet_03v3 L=0.28u W=4u nf=1  m=1
XMBNp2 ap2 p2 VSS VSS nfet_03v3 L=0.28u W=2u nf=1  m=1
XMBPp2 ap2 p2 VR VR pfet_03v3 L=0.28u W=4u nf=1  m=1
XMDNp2 L2P ap2 VSS VSS nfet_03v3 L=0.28u W=12u nf=4  m=1
XMDPp2 L2P ap2 VR VR pfet_03v3 L=0.28u W=24u nf=8  m=1
XMCNp2 ckdp2 L2P VSS VSS nfet_03v3 L=0.28u W=2u nf=1  m=1
XMCPp2 ckdp2 L2P VR VR pfet_03v3 L=0.28u W=4u nf=1  m=1
XMBNn2 an2 n2 VSS VSS nfet_03v3 L=0.28u W=2u nf=1  m=1
XMBPn2 an2 n2 VR VR pfet_03v3 L=0.28u W=4u nf=1  m=1
XMDNn2 L2N an2 VSS VSS nfet_03v3 L=0.28u W=12u nf=4  m=1
XMDPn2 L2N an2 VR VR pfet_03v3 L=0.28u W=24u nf=8  m=1
XMCNn2 ckdn2 L2N VSS VSS nfet_03v3 L=0.28u W=2u nf=1  m=1
XMCPn2 ckdn2 L2N VR VR pfet_03v3 L=0.28u W=4u nf=1  m=1
XMBNp3 ap3 p3 VSS VSS nfet_03v3 L=0.28u W=2u nf=1  m=1
XMBPp3 ap3 p3 VR VR pfet_03v3 L=0.28u W=4u nf=1  m=1
XMDNp3 L3P ap3 VSS VSS nfet_03v3 L=0.28u W=12u nf=4  m=1
XMDPp3 L3P ap3 VR VR pfet_03v3 L=0.28u W=24u nf=8  m=1
XMCNp3 ckdp3 L3P VSS VSS nfet_03v3 L=0.28u W=2u nf=1  m=1
XMCPp3 ckdp3 L3P VR VR pfet_03v3 L=0.28u W=4u nf=1  m=1
XMBNn3 an3 n3 VSS VSS nfet_03v3 L=0.28u W=2u nf=1  m=1
XMBPn3 an3 n3 VR VR pfet_03v3 L=0.28u W=4u nf=1  m=1
XMDNn3 L3N an3 VSS VSS nfet_03v3 L=0.28u W=12u nf=4  m=1
XMDPn3 L3N an3 VR VR pfet_03v3 L=0.28u W=24u nf=8  m=1
XMCNn3 ckdn3 L3N VSS VSS nfet_03v3 L=0.28u W=2u nf=1  m=1
XMCPn3 ckdn3 L3N VR VR pfet_03v3 L=0.28u W=4u nf=1  m=1
XMBNp4 ap4 p4 VSS VSS nfet_03v3 L=0.28u W=2u nf=1  m=1
XMBPp4 ap4 p4 VR VR pfet_03v3 L=0.28u W=4u nf=1  m=1
XMDNp4 L4P ap4 VSS VSS nfet_03v3 L=0.28u W=12u nf=4  m=1
XMDPp4 L4P ap4 VR VR pfet_03v3 L=0.28u W=24u nf=8  m=1
XMCNp4 ckdp4 L4P VSS VSS nfet_03v3 L=0.28u W=2u nf=1  m=1
XMCPp4 ckdp4 L4P VR VR pfet_03v3 L=0.28u W=4u nf=1  m=1
XMBNn4 an4 n4 VSS VSS nfet_03v3 L=0.28u W=2u nf=1  m=1
XMBPn4 an4 n4 VR VR pfet_03v3 L=0.28u W=4u nf=1  m=1
XMDNn4 L4N an4 VSS VSS nfet_03v3 L=0.28u W=12u nf=4  m=1
XMDPn4 L4N an4 VR VR pfet_03v3 L=0.28u W=24u nf=8  m=1
XMCNn4 ckdn4 L4N VSS VSS nfet_03v3 L=0.28u W=2u nf=1  m=1
XMCPn4 ckdn4 L4N VR VR pfet_03v3 L=0.28u W=4u nf=1  m=1
XMK1 n1 kh VSS VSS nfet_03v3 L=0.28u W=16u nf=4  m=1
XMKD1 p1 VSS VSS VSS nfet_03v3 L=0.28u W=16u nf=4  m=1
XMK2 n2 kl VSS VSS nfet_03v3 L=0.28u W=16u nf=4  m=1
XMKD2 p2 VSS VSS VSS nfet_03v3 L=0.28u W=16u nf=4  m=1
XMK3 n3 VSS VSS VSS nfet_03v3 L=0.28u W=16u nf=4  m=1
XMKD3 p3 VSS VSS VSS nfet_03v3 L=0.28u W=16u nf=4  m=1
XMK4 p4 VSS VSS VSS nfet_03v3 L=0.28u W=16u nf=4  m=1
XMKD4 n4 VSS VSS VSS nfet_03v3 L=0.28u W=16u nf=4  m=1
.ends
.subckt nor2 A B Y VDD VSS
XMN1 Y A VSS VSS nfet_03v3 L=0.28u W=1u nf=1  m=1
XMN2 Y B VSS VSS nfet_03v3 L=0.28u W=1u nf=1  m=1
XMP1 n1 A VDD VDD pfet_03v3 L=0.28u W=4u nf=1  m=1
XMP2 Y B n1 VDD pfet_03v3 L=0.28u W=4u nf=1  m=1
.ends
.subckt nand2 A B Y VDD VSS
XMN1 Y A n1 VSS nfet_03v3 L=0.28u W=2u nf=1  m=1
XMN2 n1 B VSS VSS nfet_03v3 L=0.28u W=2u nf=1  m=1
XMP1 Y A VDD VDD pfet_03v3 L=0.28u W=2u nf=1  m=1
XMP2 Y B VDD VDD pfet_03v3 L=0.28u W=2u nf=1  m=1
.ends
.subckt inv_dig A Y VDD VSS
XMN Y A VSS VSS nfet_03v3 L=0.28u W=1u nf=1  m=1
XMP Y A VDD VDD pfet_03v3 L=0.28u W=2u nf=1  m=1
.ends
.subckt vco_ring4 VCTRL B0 B1 NB L1P L1N L2P L2N L3P L3N L4P L4N CK VR VDD VSS
XMVI ng VCTRL ns VSS nfet_03v3 L=0.5u W=20u nf=4  m=1
XRDEG VSS ns VSS ppolyf_u_1k r_width=2u r_length=4u
XMPD ng ng VDD VDD pfet_03v3 L=0.56u W=80u nf=16  m=1
XMPO VR ng VDD VDD pfet_03v3 L=0.56u W=80u nf=16  m=16
XMMIN ng NB VSS VSS nfet_03v3 L=2u W=12u nf=2  m=1
XRB0 b0_i B0 VSS ppolyf_u_1k r_width=2u r_length=2u
XRB1 b1_i B1 VSS ppolyf_u_1k r_width=2u r_length=2u
XB0 b0_i b0n VDD VSS inv_dig
XB1 b1_i b1n VDD VSS inv_dig
XMPB0 nb0 ng VDD VDD pfet_03v3 L=0.56u W=80u nf=16  m=12
XMSB0 VR b0n nb0 VDD pfet_03v3 L=0.28u W=40u nf=8  m=12
XMPB1 nb1 ng VDD VDD pfet_03v3 L=0.56u W=80u nf=16  m=24
XMSB1 VR b1n nb1 VDD pfet_03v3 L=0.28u W=40u nf=8  m=24
XCVR VR VSS cap_mim_2f0_m4m5_noshield c_width=30e-6 c_length=30e-6 m=1
XCORE L1P L1N L2P L2N L3P L3N L4P L4N CK ckdn1 ckdp2 ckdn2 ckdp3 ckdn3 ckdp4 ckdn4 kh kl VR VSS vco_core
XSUA ckdp2 ckdn2 sua VR VSS nand2
XSUB ckdp2 ckdn2 sub VR VSS nor2
XSUAD1 CK ckdn1 suad1 VR VSS nand2
XSUBD1 CK ckdn1 subd1 VR VSS nor2
XSUAD3 ckdp3 ckdn3 suad3 VR VSS nand2
XSUBD3 ckdp3 ckdn3 subd3 VR VSS nor2
XSUAD4 ckdp4 ckdn4 suad4 VR VSS nand2
XSUBD4 ckdp4 ckdn4 subd4 VR VSS nor2
XRSUA fsua sua VSS ppolyf_u_1k r_width=1u r_length=100u
XCSUA fsua VSS cap_mim_2f0_m4m5_noshield c_width=5e-6 c_length=5e-6 m=1
XRSUB fsub sub VSS ppolyf_u_1k r_width=1u r_length=100u
XCSUB fsub VSS cap_mim_2f0_m4m5_noshield c_width=5e-6 c_length=5e-6 m=1
XSUA1 sua fsua kh VR VSS nor2
XSUA2 kh khn VR VSS inv_dig
XSUB1 sub fsub kln VR VSS nand2
XSUB2 kln kl VR VSS inv_dig
.ends
